** sch_path: /home/student/ee5311/Wallace/wallace.sch
* expanding   symbol:  fa.sym # of pins=7
** sym_path: /home/student/ee5311/Wallace/fa.sym
** sch_path: /home/student/ee5311/Wallace/fa.sch
.subckt fa DVDD DGND A B CIN COUTB SUMB
*.PININFO COUTB:O CIN:I DVDD:B DGND:B SUMB:O B:I A:I
XM3 SUMB CIN net4 DGND sky130_fd_pr__nfet_01v8 L=0.15 W=0.42 nf=1
XM1 net2 A DVDD DVDD sky130_fd_pr__pfet_01v8 L=0.15 W=0.42 nf=1
XM2 net1 B net2 DVDD sky130_fd_pr__pfet_01v8 L=0.15 W=0.42 nf=1
XM4 SUMB CIN net1 DVDD sky130_fd_pr__pfet_01v8 L=0.15 W=0.42 nf=1
XM5 net4 B net3 DGND sky130_fd_pr__nfet_01v8 L=0.15 W=0.42 nf=1
XM6 net3 A DGND DGND sky130_fd_pr__nfet_01v8 L=0.15 W=0.42 nf=1
XM7 net5 A DVDD DVDD sky130_fd_pr__pfet_01v8 L=0.15 W=0.42 nf=1
XM8 net5 B DVDD DVDD sky130_fd_pr__pfet_01v8 L=0.15 W=0.42 nf=1
XM9 net5 CIN DVDD DVDD sky130_fd_pr__pfet_01v8 L=0.15 W=0.42 nf=1
XM10 SUMB COUTB net5 DVDD sky130_fd_pr__pfet_01v8 L=0.15 W=0.42 nf=1
XM11 net6 A DGND DGND sky130_fd_pr__nfet_01v8 L=0.15 W=0.42 nf=1
XM12 net6 B DGND DGND sky130_fd_pr__nfet_01v8 L=0.15 W=0.42 nf=1
XM13 net6 CIN DGND DGND sky130_fd_pr__nfet_01v8 L=0.15 W=0.42 nf=1
XM14 SUMB COUTB net6 DGND sky130_fd_pr__nfet_01v8 L=0.15 W=0.42 nf=1
XM15 COUTB CIN net10 DGND sky130_fd_pr__nfet_01v8 L=0.15 W=0.42 nf=1
XM16 net7 A DVDD DVDD sky130_fd_pr__pfet_01v8 L=0.15 W=0.42 nf=1
XM17 COUTB B net7 DVDD sky130_fd_pr__pfet_01v8 L=0.15 W=0.42 nf=1
XM18 COUTB CIN net9 DVDD sky130_fd_pr__pfet_01v8 L=0.15 W=0.42 nf=1
XM19 COUTB B net8 DGND sky130_fd_pr__nfet_01v8 L=0.15 W=0.42 nf=1
XM20 net8 A DGND DGND sky130_fd_pr__nfet_01v8 L=0.15 W=0.42 nf=1
XM21 net9 A DVDD DVDD sky130_fd_pr__pfet_01v8 L=0.15 W=0.42 nf=1
XM22 net9 B DVDD DVDD sky130_fd_pr__pfet_01v8 L=0.15 W=0.42 nf=1
XM23 net10 A DGND DGND sky130_fd_pr__nfet_01v8 L=0.15 W=0.42 nf=1
XM24 net10 B DGND DGND sky130_fd_pr__nfet_01v8 L=0.15 W=0.42 nf=1
.ends

* expanding   symbol:  xor2.sym # of pins=5
** sym_path: /home/student/ee5311/Wallace/xor2.sym
** sch_path: /home/student/ee5311/Wallace/xor2.sch
.subckt xor2 DVDD A B Y DGND
*.PININFO DVDD:B DGND:B A:I B:I Y:O
XM2 Y net1 net2 DVDD sky130_fd_pr__pfet_01v8 L=0.15 W=1.00 nf=1
XM1 Y net1 DGND DGND sky130_fd_pr__nfet_01v8 L=0.15 W=0.65 nf=1
XM3 net1 B net3 DVDD sky130_fd_pr__pfet_01v8 L=0.15 W=1.00 nf=1
XM4 net3 A DVDD DVDD sky130_fd_pr__pfet_01v8 L=0.15 W=1.00 nf=1
XM5 net1 A DGND DGND sky130_fd_pr__nfet_01v8 L=0.15 W=0.65 nf=1
XM6 net1 B DGND DGND sky130_fd_pr__nfet_01v8 L=0.15 W=0.65 nf=1
XM7 Y B net4 DGND sky130_fd_pr__nfet_01v8 L=0.15 W=0.65 nf=1
XM8 net4 A DGND DGND sky130_fd_pr__nfet_01v8 L=0.15 W=0.65 nf=1
XM9 net2 A DVDD DVDD sky130_fd_pr__pfet_01v8 L=0.15 W=1.00 nf=1
XM10 net2 B DVDD DVDD sky130_fd_pr__pfet_01v8 L=0.15 W=1.00 nf=1
.ends

* expanding   symbol:  inv.sym # of pins=4
** sym_path: /home/student/ee5311/Wallace/inv.sym
** sch_path: /home/student/ee5311/Wallace/inv.sch
.subckt inv A Y DVDD DGND
*.PININFO Y:O A:I DVDD:B DGND:B
XM2 Y A DVDD DVDD sky130_fd_pr__pfet_01v8 L=0.15 W=1.00 nf=1
XM1 Y A DGND DGND sky130_fd_pr__nfet_01v8 L=0.15 W=0.65 nf=1
.ends

* expanding   symbol:  nand4.sym # of pins=7
** sym_path: /home/student/ee5311/Wallace/nand4.sym
** sch_path: /home/student/ee5311/Wallace/nand4.sch
.subckt nand4 DVDD A B C D Y DGND
*.PININFO Y:O A:I DVDD:B DGND:B B:I C:I D:I
XM2 Y B DVDD DVDD sky130_fd_pr__pfet_01v8 L=0.15 W=1.00 nf=1
XM1 Y A net1 DGND sky130_fd_pr__nfet_01v8 L=0.15 W=0.65 nf=1
XM3 net1 B net2 DGND sky130_fd_pr__nfet_01v8 L=0.15 W=0.65 nf=1
XM4 net2 C net3 DGND sky130_fd_pr__nfet_01v8 L=0.15 W=0.65 nf=1
XM5 net3 D DGND DGND sky130_fd_pr__nfet_01v8 L=0.15 W=0.65 nf=1
XM6 Y A DVDD DVDD sky130_fd_pr__pfet_01v8 L=0.15 W=1.00 nf=1
XM7 Y C DVDD DVDD sky130_fd_pr__pfet_01v8 L=0.15 W=1.00 nf=1
XM8 Y D DVDD DVDD sky130_fd_pr__pfet_01v8 L=0.15 W=1.00 nf=1
.ends

* expanding   symbol:  stage3.sym # of pins=33
** sym_path: /home/student/ee5311/Wallace/stage3.sym
** sch_path: /home/student/ee5311/Wallace/stage3.sch
.subckt stage3 DVDD a1 a3 P1 a4 S22 S24 S23 S25 a5 C24 C23 C22 a0 C25 a2 b0 b1 b2 b3 DGND b4 b5 S28 S27 S26 S29 C28 C27 C26 P0 P2
+ X11
*.PININFO a1:I a3:I a4:I a5:I a0:I a2:I b0:I b1:I b2:I b3:I b4:I b5:I P1:O P0:O P2:O C22:O S23:O C23:O S24:O C24:O S25:O C25:O
*+ S26:O C26:O S27:O C27:O S28:O C28:O S29:O X11:O S22:O DVDD:B DGND:B
x2 DVDD DGND S14 C13 DVDD C22 S22 fa
x3 DVDD DGND S15 C14 DVDD C23 S23 fa
x4 DVDD DGND S16 C15 I5 C24 S24 fa
x5 DVDD DGND S17 C16 I6 C25 S25 fa
x6 DVDD DGND S18 C17 pn25 C26 S26 fa
x7 DVDD DGND S19 C18 DVDD C27 S27 fa
x8 DVDD DGND S20 C19 DVDD C28 S28 fa
x9 DVDD DGND S21 C20 DVDD C29 S29 fa
x11 DVDD C21 C29 X11 DGND xor2
x1 DVDD a1 a3 P1 a4 S16 S15 S14 a5 C16 C15 C14 C13 a0 a2 b0 b1 b2 DGND b3 b4 b5 S17 S20 S19 S18 C17 C20 C19 C18 S21 I6 P0 I5 P2
+ C21 pn25 stage2
.ends

* expanding   symbol:  mux2.sym # of pins=6
** sym_path: /home/student/ee5311/Wallace/mux2.sym
** sch_path: /home/student/ee5311/Wallace/mux2.sch
.subckt mux2 DVDD S A0 A1 X DGND
*.PININFO DVDD:B DGND:B A0:I A1:I S:I X:O
XM2 X net1 DVDD DVDD sky130_fd_pr__pfet_01v8 L=0.15 W=1.00 nf=1
XM1 X net1 DGND DGND sky130_fd_pr__nfet_01v8 L=0.15 W=0.65 nf=1
XM3 net2 S DVDD DVDD sky130_fd_pr__pfet_01v8 L=0.15 W=0.42 nf=1
XM4 net1 A0 net2 DVDD sky130_fd_pr__pfet_01v8 L=0.15 W=0.42 nf=1
XM5 Sb S DVDD DVDD sky130_fd_pr__pfet_01v8 L=0.15 W=0.42 nf=1
XM6 Sb S DGND DGND sky130_fd_pr__nfet_01v8 L=0.15 W=0.42 nf=1
XM7 net1 A0 net3 DGND sky130_fd_pr__nfet_01v8 L=0.15 W=0.42 nf=1
XM8 net3 Sb DGND DGND sky130_fd_pr__nfet_01v8 L=0.15 W=0.42 nf=1
XM9 net4 Sb DVDD DVDD sky130_fd_pr__pfet_01v8 L=0.15 W=0.42 nf=1
XM10 net1 A1 net4 DVDD sky130_fd_pr__pfet_01v8 L=0.15 W=0.42 nf=1
XM11 net1 A1 net5 DGND sky130_fd_pr__nfet_01v8 L=0.15 W=0.42 nf=1
XM12 net5 S DGND DGND sky130_fd_pr__nfet_01v8 L=0.15 W=0.42 nf=1
.ends

* expanding   symbol:  stage2.sym # of pins=37
** sym_path: /home/student/ee5311/Wallace/stage2.sym
** sch_path: /home/student/ee5311/Wallace/stage2.sch
.subckt stage2 DVDD a1 a3 P1 a4 S16 S15 S14 a5 C16 C15 C14 C13 a0 a2 b0 b1 b2 DGND b3 b4 b5 S17 S20 S19 S18 C17 C20 C19 C18 S21 I6
+ P0 I5 P2 C21 pn25
*.PININFO a1:I a3:I a4:I a5:I a0:I a2:I b0:I b1:I b2:I b3:I b4:I b5:I P0:O DGND:B DVDD:B P1:O C13:O S14:O C14:O S15:O C15:O S16:O
*+ C16:O S17:O C17:O S18:O C18:O S19:O C19:O S20:O C20:O S21:O C21:O P2:O I5:O I6:O pn25:O
x2 DVDD DGND S2 C1 DGND C13 S13 fa
x3 DVDD DGND I3 S3 C2 C14 S14 fa
x4 DVDD DGND S4 S5 C3 C15 S15 fa
x5 DVDD DGND S6 C5 C4 C16 S16 fa
x6 DVDD DGND S8 C7 C6 C17 S17 fa
x7 DVDD DGND S10 C9 C8 C18 S18 fa
x8 DVDD DGND S11 C10 DGND C19 S19 fa
x9 DVDD DGND S12 C11 DGND C20 S20 fa
x10 DVDD DGND I10 C12 DGND C21 S21 fa
x11 S13 P2 DVDD DGND inv
x12 S7 I5 DVDD DGND inv
x13 S9 I6 DVDD DGND inv
x1 DVDD a1 P1 S2 S3 a3 a4 a5 a0 S4 a2 C2 C4 b0 C3 C1 DGND S7 S6 S5 S8 b1 C7 C6 C5 C8 b2 S9 S11 S10 S12 C11 C10 C9 C12 b3 I10 I3 P0
+ b4 pn25 b5 stage1
.ends

* expanding   symbol:  stage1.sym # of pins=42
** sym_path: /home/student/ee5311/Wallace/stage1.sym
** sch_path: /home/student/ee5311/Wallace/stage1.sch
.subckt stage1 DVDD a1 S1 S2 S3 a3 a4 a5 a0 S4 a2 C2 C4 b0 C3 C1 DGND S7 S6 S5 S8 b1 C7 C6 C5 C8 b2 S9 S11 S10 S12 C11 C10 C9 C12
+ b3 I10 I3 P0 b4 pn25 b5
*.PININFO DVDD:B DGND:B a0:I b0:I a1:I a2:I a3:I a4:I a5:I b1:I b2:I b3:I b4:I b5:I S1:O C1:O S2:O C2:O S3:O C3:O S4:O C4:O S5:O
*+ C5:O S6:O C6:O S7:O C7:O S8:O C8:O S9:O C9:O S10:O C10:O S11:O C11:O S12:O C12:O pn25:O P0:O I3:O I10:O
x1 DVDD a0 b0 pn00 DGND nand2
x2 DVDD a1 b0 pn10 DGND nand2
x3 DVDD a2 b0 pn20 DGND nand2
x4 DVDD a3 b0 pn30 DGND nand2
x5 DVDD a4 b0 pn40 DGND nand2
x6 DVDD a5 b0 pn50 DGND nand2
x7 DVDD a0 b1 pn01 DGND nand2
x8 DVDD a1 b1 pn11 DGND nand2
x9 DVDD a2 b1 pn21 DGND nand2
x10 DVDD a3 b1 pn31 DGND nand2
x11 DVDD a4 b1 pn41 DGND nand2
x12 DVDD a5 b1 pn51 DGND nand2
x13 DVDD a0 b2 pn02 DGND nand2
x14 DVDD a1 b2 pn12 DGND nand2
x15 DVDD a2 b2 pn22 DGND nand2
x16 DVDD a3 b2 pn32 DGND nand2
x17 DVDD a4 b2 pn42 DGND nand2
x18 DVDD a5 b2 pn52 DGND nand2
x19 DVDD a0 b3 pn03 DGND nand2
x20 DVDD a1 b3 pn13 DGND nand2
x21 DVDD a2 b3 pn23 DGND nand2
x22 DVDD a3 b3 pn33 DGND nand2
x23 DVDD a4 b3 pn43 DGND nand2
x24 DVDD a5 b3 pn53 DGND nand2
x25 DVDD a0 b4 pn04 DGND nand2
x26 DVDD a1 b4 pn14 DGND nand2
x27 DVDD a2 b4 pn24 DGND nand2
x28 DVDD a3 b4 pn34 DGND nand2
x29 DVDD a4 b4 pn44 DGND nand2
x30 DVDD a5 b4 pn54 DGND nand2
x31 DVDD a0 b5 pn05 DGND nand2
x32 DVDD a1 b5 pn15 DGND nand2
x33 DVDD a2 b5 pn25 DGND nand2
x34 DVDD a3 b5 pn35 DGND nand2
x35 DVDD a4 b5 pn45 DGND nand2
x36 DVDD a5 b5 pn55 DGND nand2
x37 DVDD DGND pn10 pn01 DVDD C1 S1 fa
x38 DVDD DGND pn20 pn11 pn02 C2 S2 fa
x39 DVDD DGND pn30 pn21 pn12 C3 S3 fa
x40 DVDD DGND pn40 pn31 pn22 C4 S4 fa
x41 DVDD DGND pn13 pn04 DVDD C5 S5 fa
x42 DVDD DGND pn50 pn41 pn32 C6 S6 fa
x43 DVDD DGND pn23 pn14 pn05 C7 S7 fa
x44 DVDD DGND pn51 pn42 pn33 C8 S8 fa
x45 DVDD DGND pn24 pn15 DVDD C9 S9 fa
x46 DVDD DGND pn52 pn43 pn34 C10 S10 fa
x47 DVDD DGND pn53 pn44 pn35 C11 S11 fa
x48 DVDD DGND pn54 pn45 DVDD C12 S12 fa
x49 pn00 P0 DVDD DGND inv
x50 pn03 I3 DVDD DGND inv
x51 pn55 I10 DVDD DGND inv
.ends

* expanding   symbol:  nand2.sym # of pins=5
** sym_path: /home/student/ee5311/Wallace/nand2.sym
** sch_path: /home/student/ee5311/Wallace/nand2.sch
.subckt nand2 DVDD A B Y DGND
*.PININFO Y:O A:I DVDD:B DGND:B B:I
XM2 Y A DVDD DVDD sky130_fd_pr__pfet_01v8 L=0.15 W=1.00 nf=1
XM1 Y A net1 DGND sky130_fd_pr__nfet_01v8 L=0.15 W=0.65 nf=1
XM3 net1 B DGND DGND sky130_fd_pr__nfet_01v8 L=0.15 W=0.65 nf=1
XM7 Y B DVDD DVDD sky130_fd_pr__pfet_01v8 L=0.15 W=1.00 nf=1
.ends
.subckt wallace DVDD a1 P1 a3 P3 P7 a4 P5 a5 a0 a2 b0 b1 b2 b3 DGND b4 b5 P9 P11 P0 P2 P10 P8 P6 P4
*.PININFO a1:I a3:I a4:I a5:I a0:I a2:I b0:I b1:I b2:I b3:I b4:I b5:I DVDD:B DGND:B P1:O P3:O P0:O P2:O P11:O P9:O P7:O P5:O P4:O
*+ P6:O P8:O P10:O
x2 DVDD DGND S23 C22 DGND C30 S30 fa
x3 DVDD DGND IS24 IC23 C30 C31 P5 fa
x4 DVDD DGND S25 C24 C31 C32 S32 fa
x5 DVDD DGND IS26 IC25 C32 C33 P7 fa
x6 DVDD DGND S27 C26 C33 C34 S34 fa
x7 DVDD DGND IS28 IC27 C34 C35 P9 fa
x8 DVDD DGND S29 C28 X10 C36 S36 fa
x9 DVDD X11 C36 P11 DGND xor2
x10 S30 P4 DVDD DGND inv
x11 S32 P6 DVDD DGND inv
x12 S34 P8 DVDD DGND inv
x13 S36 P10 DVDD DGND inv
x14 S24 IS24 DVDD DGND inv
x15 C23 IC23 DVDD DGND inv
x16 S26 IS26 DVDD DGND inv
x17 C25 IC25 DVDD DGND inv
x18 S28 IS28 DVDD DGND inv
x19 C27 IC27 DVDD DGND inv
x21 C32 IC32 DVDD DGND inv
x22 DVDD pr7 pr8 pr9 DVDD nP DGND nand4
x23 DVDD S26 C25 pr7 DGND xor2
x20 DVDD S27 C26 pr8 DGND xor2
x25 DVDD S28 C27 pr9 DGND xor2
x1 DVDD a1 a3 P1 a4 P3 S24 S23 S25 a5 C24 C23 C22 a0 C25 a2 b0 b1 b2 b3 DGND b4 b5 S28 S27 S26 S29 C28 C27 C26 P0 P2 X11 stage3
x24 DVDD nP IC32 C35 X10 DGND mux2
.ends
