* NGSPICE file created from wallace.ext - technology: sky130A

.subckt wallace DVDD a1 P1 a3 P3 P7 a4 P5 a5 a0 a2 b0 b1 b2 b3 DGND b4 b5 P9 P11 P0
+ P2 P10 P8 P6 P4
X0 a_2367_5487# a_2325_5713# a_2283_5487# DVDD.t25 sky130_fd_pr__pfet_01v8 ad=0.0567 pd=0.69 as=0.0567 ps=0.69 w=0.42 l=0.15
X1 a_961_1831# a_395_2344# a_975_3311# DVDD.t511 sky130_fd_pr__pfet_01v8 ad=0.0693 pd=0.75 as=0.06195 ps=0.715 w=0.42 l=0.15
X2 a_849_3017# a4.t0 a_849_2767# DGND.t643 sky130_fd_pr__nfet_01v8 ad=0.169 pd=1.82 as=0.08775 ps=0.92 w=0.65 l=0.15
X3 DGND.t382 a_1697_6807.t4 a_2688_6941# DGND.t381 sky130_fd_pr__nfet_01v8 ad=0.1176 pd=1.4 as=0.0693 ps=0.75 w=0.42 l=0.15
X4 a_2493_1929# a_553_1679# DVDD.t561 DVDD.t560 sky130_fd_pr__pfet_01v8 ad=0.135 pd=1.27 as=0.135 ps=1.27 w=1 l=0.15
X5 a_721_1501# a_685_1367# DGND.t58 DGND.t57 sky130_fd_pr__nfet_01v8 ad=0.063 pd=0.72 as=0.1596 ps=1.6 w=0.42 l=0.15
X6 a_1251_1135# a_685_1367# DVDD.t58 DVDD.t57 sky130_fd_pr__pfet_01v8 ad=0.06195 pd=0.715 as=0.0567 ps=0.69 w=0.42 l=0.15
X7 a_1775_6696# a_627_5487# a_3573_6941# DGND.t235 sky130_fd_pr__nfet_01v8 ad=0.0567 pd=0.69 as=0.063 ps=0.72 w=0.42 l=0.15
X8 a_4115_5853# a_3983_5608# DGND.t657 DGND.t656 sky130_fd_pr__nfet_01v8 ad=0.1092 pd=1.36 as=0.0567 ps=0.69 w=0.42 l=0.15
X9 a_619_3677# DVDD.t944 a_395_2344# DGND.t769 sky130_fd_pr__nfet_01v8 ad=0.0567 pd=0.69 as=0.0567 ps=0.69 w=0.42 l=0.15
X10 a_485_749# a_1775_854# a_1733_957# DVDD.t608 sky130_fd_pr__pfet_01v8 ad=0.0567 pd=0.69 as=0.063 ps=0.72 w=0.42 l=0.15
X11 a_4877_1679# a_4847_1653# a_4793_1679# DGND.t111 sky130_fd_pr__nfet_01v8 ad=0.10725 pd=0.98 as=0.08775 ps=0.92 w=0.65 l=0.15
X12 DVDD.t36 a5.t0 a_757_6281# DVDD.t35 sky130_fd_pr__pfet_01v8 ad=0.26 pd=2.52 as=0.135 ps=1.27 w=1 l=0.15
X13 DGND.t444 a_2249_3543# a_3240_3677# DGND.t443 sky130_fd_pr__nfet_01v8 ad=0.1176 pd=1.4 as=0.0693 ps=0.75 w=0.42 l=0.15
X14 a_2235_1256# a_2467_2223# a_3297_1679# DGND.t220 sky130_fd_pr__nfet_01v8 ad=0.0567 pd=0.69 as=0.063 ps=0.72 w=0.42 l=0.15
X15 a_5219_6031# a_3387_6031# DGND.t213 DGND.t212 sky130_fd_pr__nfet_01v8 ad=0.1092 pd=1.36 as=0.0567 ps=0.69 w=0.42 l=0.15
X16 a_6092_3855# a_4031_5487# a_6020_3855# DGND.t367 sky130_fd_pr__nfet_01v8 ad=0.0693 pd=0.75 as=0.0441 ps=0.63 w=0.42 l=0.15
X17 a_2551_2589# a_1125_3017# a_2467_2223# DGND.t436 sky130_fd_pr__nfet_01v8 ad=0.0567 pd=0.69 as=0.0567 ps=0.69 w=0.42 l=0.15
X18 a_1775_5206.t0 a_5135_6031# DGND.t34 DGND.t33 sky130_fd_pr__nfet_01v8 ad=0.169 pd=1.82 as=0.169 ps=1.82 w=0.65 l=0.15
X19 a_2723_5853# a_2235_5608# DGND.t508 DGND.t507 sky130_fd_pr__nfet_01v8 ad=0.0567 pd=0.69 as=0.1092 ps=1.36 w=0.42 l=0.15
X20 DVDD.t334 a2.t0 a_2417_4625# DVDD.t333 sky130_fd_pr__pfet_01v8 ad=0.26 pd=2.52 as=0.135 ps=1.27 w=1 l=0.15
X21 DVDD.t226 a2.t1 a_3609_4399# DVDD.t225 sky130_fd_pr__pfet_01v8 ad=0.26 pd=2.52 as=0.135 ps=1.27 w=1 l=0.15
X22 a_2249_3543# b1.t0 DVDD.t500 DVDD.t499 sky130_fd_pr__pfet_01v8 ad=0.135 pd=1.27 as=0.26 ps=2.52 w=1 l=0.15
X23 P7.t2 a_1865_749# a_5023_957# DVDD.t458 sky130_fd_pr__pfet_01v8 ad=0.0693 pd=0.75 as=0.06195 ps=0.715 w=0.42 l=0.15
X24 DVDD.t56 a_685_1367# a_1676_1135# DVDD.t55 sky130_fd_pr__pfet_01v8 ad=0.1575 pd=1.59 as=0.0693 ps=0.75 w=0.42 l=0.15
X25 a_2520_3855# a_1823_3855# a_2263_3855# DGND.t294 sky130_fd_pr__nfet_01v8 ad=0.0693 pd=0.75 as=0.06195 ps=0.715 w=0.42 l=0.15
X26 a_1987_2767# a_849_3017# DGND.t459 DGND.t458 sky130_fd_pr__nfet_01v8 ad=0.0567 pd=0.69 as=0.1092 ps=1.36 w=0.42 l=0.15
X27 a_443_591# a_395_854# a_353_591# DGND.t175 sky130_fd_pr__nfet_01v8 ad=0.0567 pd=0.69 as=0.063 ps=0.72 w=0.42 l=0.15
X28 DGND.t885 a_4457_743# a_5448_591# DGND.t884 sky130_fd_pr__nfet_01v8 ad=0.1176 pd=1.4 as=0.0693 ps=0.75 w=0.42 l=0.15
X29 a_6047_2045# a_5779_4943# DVDD.t897 DVDD.t896 sky130_fd_pr__pfet_01v8 ad=0.1092 pd=1.36 as=0.0567 ps=0.69 w=0.42 l=0.15
X30 a_501_5719# a_1455_6031# a_1895_6397# DVDD.t451 sky130_fd_pr__pfet_01v8 ad=0.0693 pd=0.75 as=0.06195 ps=0.715 w=0.42 l=0.15
X31 a_5188_2223# a_1775_854# a_4931_2589# DGND.t551 sky130_fd_pr__nfet_01v8 ad=0.0693 pd=0.75 as=0.06195 ps=0.715 w=0.42 l=0.15
X32 a_3827_6397# a_3261_6183# DVDD.t551 DVDD.t550 sky130_fd_pr__pfet_01v8 ad=0.06195 pd=0.715 as=0.0567 ps=0.69 w=0.42 l=0.15
X33 a_3827_6031# a_2980_5487# DGND.t637 DGND.t636 sky130_fd_pr__nfet_01v8 ad=0.0567 pd=0.69 as=0.1092 ps=1.36 w=0.42 l=0.15
X34 a_3240_3311# a_2327_3432# a_3168_3311# DVDD.t206 sky130_fd_pr__pfet_01v8 ad=0.0693 pd=0.75 as=0.0441 ps=0.63 w=0.42 l=0.15
X35 a_3827_2045# a_2467_2223# DVDD.t244 DVDD.t243 sky130_fd_pr__pfet_01v8 ad=0.0567 pd=0.69 as=0.1092 ps=1.36 w=0.42 l=0.15
X36 a_947_4520# a4.t1 a_1401_3855# DGND.t642 sky130_fd_pr__nfet_01v8 ad=0.169 pd=1.82 as=0.08775 ps=0.92 w=0.65 l=0.15
X37 a_2459_3311# a_849_4105# a_2375_3311# DVDD.t165 sky130_fd_pr__pfet_01v8 ad=0.0567 pd=0.69 as=0.0567 ps=0.69 w=0.42 l=0.15
X38 a_5177_1929# a_1775_854# a_5095_1929# DVDD.t607 sky130_fd_pr__pfet_01v8 ad=0.135 pd=1.27 as=0.26 ps=2.52 w=1 l=0.15
X39 DVDD.t533 a_961_1831# a_1171_2045# DVDD.t532 sky130_fd_pr__pfet_01v8 ad=0.0567 pd=0.69 as=0.0567 ps=0.69 w=0.42 l=0.15
X40 a_2520_6575# a_1823_6575# a_2263_6575# DVDD.t274 sky130_fd_pr__pfet_01v8 ad=0.0693 pd=0.75 as=0.06195 ps=0.715 w=0.42 l=0.15
X41 DGND.t331 a_1784_1679# a_2367_1501# DGND.t330 sky130_fd_pr__nfet_01v8 ad=0.0567 pd=0.69 as=0.0567 ps=0.69 w=0.42 l=0.15
X42 a_4351_5206# a_4031_5487# a_4471_5487# DVDD.t391 sky130_fd_pr__pfet_01v8 ad=0.0693 pd=0.75 as=0.06195 ps=0.715 w=0.42 l=0.15
X43 a_5192_5309# a_2283_5487# a_5009_6183# DVDD.t576 sky130_fd_pr__pfet_01v8 ad=0.0441 pd=0.63 as=0.0693 ps=0.75 w=0.42 l=0.15
X44 a_5448_591# a_4535_854# a_5376_591# DGND.t206 sky130_fd_pr__nfet_01v8 ad=0.0693 pd=0.75 as=0.0441 ps=0.63 w=0.42 l=0.15
X45 DGND.t360 a_2157_5719# a_3148_5853# DGND.t359 sky130_fd_pr__nfet_01v8 ad=0.1176 pd=1.4 as=0.0693 ps=0.75 w=0.42 l=0.15
X46 DVDD.t273 a_1823_6575# a_2263_5309# DVDD.t272 sky130_fd_pr__pfet_01v8 ad=0.0567 pd=0.69 as=0.0567 ps=0.69 w=0.42 l=0.15
X47 a_3076_1501# DVDD.t945 a_2980_1135# DGND.t768 sky130_fd_pr__nfet_01v8 ad=0.0441 pd=0.63 as=0.0693 ps=0.75 w=0.42 l=0.15
X48 a_4943_1653# a_5503_2767# a_6173_2543# DGND.t31 sky130_fd_pr__nfet_01v8 ad=0.25025 pd=1.42 as=0.08775 ps=0.92 w=0.65 l=0.15
X49 a_711_5853# a_443_4943# DGND.t683 DGND.t682 sky130_fd_pr__nfet_01v8 ad=0.1092 pd=1.36 as=0.0567 ps=0.69 w=0.42 l=0.15
X50 a_1236_4943# DVDD.t946 P1.t3 DGND.t767 sky130_fd_pr__nfet_01v8 ad=0.0441 pd=0.63 as=0.0693 ps=0.75 w=0.42 l=0.15
X51 DVDD.t228 a2.t2 a_1329_6183# DVDD.t227 sky130_fd_pr__pfet_01v8 ad=0.26 pd=2.52 as=0.135 ps=1.27 w=1 l=0.15
X52 DVDD.t446 a_2375_4399# a_5667_4221# DVDD.t445 sky130_fd_pr__pfet_01v8 ad=0.0567 pd=0.69 as=0.0567 ps=0.69 w=0.42 l=0.15
X53 a_2045_2223# b3.t0 DVDD.t282 DVDD.t281 sky130_fd_pr__pfet_01v8 ad=0.135 pd=1.27 as=0.26 ps=2.52 w=1 l=0.15
X54 a_5376_957# a_4625_749# P7.t0 DVDD.t289 sky130_fd_pr__pfet_01v8 ad=0.0441 pd=0.63 as=0.0693 ps=0.75 w=0.42 l=0.15
X55 DGND.t149 a_4533_2449# a_4931_2589# DGND.t148 sky130_fd_pr__nfet_01v8 ad=0.0567 pd=0.69 as=0.0567 ps=0.69 w=0.42 l=0.15
X56 a_2689_6031# b2.t0 DGND.t688 DGND.t687 sky130_fd_pr__nfet_01v8 ad=0.08775 pd=0.92 as=0.169 ps=1.82 w=0.65 l=0.15
X57 DGND.t502 a_3261_6183# a_4252_6031# DGND.t501 sky130_fd_pr__nfet_01v8 ad=0.1176 pd=1.4 as=0.0693 ps=0.75 w=0.42 l=0.15
X58 a_4471_4765# a_3983_4520# DGND.t145 DGND.t144 sky130_fd_pr__nfet_01v8 ad=0.0567 pd=0.69 as=0.1092 ps=1.36 w=0.42 l=0.15
X59 DVDD.t657 a_3537_1367# a_3747_1135# DVDD.t656 sky130_fd_pr__pfet_01v8 ad=0.0567 pd=0.69 as=0.0567 ps=0.69 w=0.42 l=0.15
X60 DVDD.t441 a_2244_2767# a_4252_2045# DVDD.t440 sky130_fd_pr__pfet_01v8 ad=0.1575 pd=1.59 as=0.0693 ps=0.75 w=0.42 l=0.15
X61 a_4456_1135# DVDD.t825 a_1697_743# DVDD.t826 sky130_fd_pr__pfet_01v8 ad=0.0441 pd=0.63 as=0.0693 ps=0.75 w=0.42 l=0.15
X62 a_1697_743# a_3663_1135# a_4103_1501# DGND.t245 sky130_fd_pr__nfet_01v8 ad=0.0693 pd=0.75 as=0.06195 ps=0.715 w=0.42 l=0.15
X63 a_6173_2223# a_5188_2223# DVDD.t179 DVDD.t178 sky130_fd_pr__pfet_01v8 ad=0.135 pd=1.27 as=0.135 ps=1.27 w=1 l=0.15
X64 a_1539_6031# a_481_6281# DGND.t824 DGND.t823 sky130_fd_pr__nfet_01v8 ad=0.1092 pd=1.36 as=0.0567 ps=0.69 w=0.42 l=0.15
X65 DVDD.t433 a_1865_4013# a_2263_4221# DVDD.t432 sky130_fd_pr__pfet_01v8 ad=0.0567 pd=0.69 as=0.0567 ps=0.69 w=0.42 l=0.15
X66 a_4824_4765# a_4073_4625# a_4728_4399# DGND.t21 sky130_fd_pr__nfet_01v8 ad=0.0441 pd=0.63 as=0.0693 ps=0.75 w=0.42 l=0.15
X67 a_2193_1501# a_1784_1679# DGND.t329 DGND.t328 sky130_fd_pr__nfet_01v8 ad=0.063 pd=0.72 as=0.1596 ps=1.6 w=0.42 l=0.15
X68 a_2907_2223# a_2341_2455# DVDD.t649 DVDD.t648 sky130_fd_pr__pfet_01v8 ad=0.06195 pd=0.715 as=0.0567 ps=0.69 w=0.42 l=0.15
X69 a_573_3855# b5.t0 DGND.t721 DGND.t720 sky130_fd_pr__nfet_01v8 ad=0.08775 pd=0.92 as=0.169 ps=1.82 w=0.65 l=0.15
X70 DGND.t323 a_317_743# a_1308_591# DGND.t322 sky130_fd_pr__nfet_01v8 ad=0.1176 pd=1.4 as=0.0693 ps=0.75 w=0.42 l=0.15
X71 a_1421_2919# a5.t1 a_1769_2543# DGND.t725 sky130_fd_pr__nfet_01v8 ad=0.169 pd=1.82 as=0.08775 ps=0.92 w=0.65 l=0.15
X72 a_259_1831# a_763_1256# a_721_1501# DGND.t290 sky130_fd_pr__nfet_01v8 ad=0.0567 pd=0.69 as=0.063 ps=0.72 w=0.42 l=0.15
X73 a_5943_3133# a_5227_3855# DVDD.t73 DVDD.t72 sky130_fd_pr__pfet_01v8 ad=0.0567 pd=0.69 as=0.1092 ps=1.36 w=0.42 l=0.15
X74 a_527_4943# DVDD.t947 a_443_4943# DGND.t766 sky130_fd_pr__nfet_01v8 ad=0.0567 pd=0.69 as=0.0567 ps=0.69 w=0.42 l=0.15
X75 a_1865_749# a_4535_854# a_4493_591# DGND.t205 sky130_fd_pr__nfet_01v8 ad=0.0567 pd=0.69 as=0.063 ps=0.72 w=0.42 l=0.15
X76 DVDD.t647 a_2341_2455# a_3332_2223# DVDD.t646 sky130_fd_pr__pfet_01v8 ad=0.1575 pd=1.59 as=0.0693 ps=0.75 w=0.42 l=0.15
X77 a_353_591# a_317_743# DGND.t321 DGND.t320 sky130_fd_pr__nfet_01v8 ad=0.063 pd=0.72 as=0.1596 ps=1.6 w=0.42 l=0.15
X78 a_3573_1135# a_3537_1367# DVDD.t655 DVDD.t654 sky130_fd_pr__pfet_01v8 ad=0.063 pd=0.72 as=0.1575 ps=1.59 w=0.42 l=0.15
X79 a_2263_6941# a_1775_6696# DGND.t451 DGND.t450 sky130_fd_pr__nfet_01v8 ad=0.0567 pd=0.69 as=0.1092 ps=1.36 w=0.42 l=0.15
X80 DGND.t877 a_3072_4399# a_5264_4943# DGND.t876 sky130_fd_pr__nfet_01v8 ad=0.1176 pd=1.4 as=0.0693 ps=0.75 w=0.42 l=0.15
X81 a_1308_591# a_395_854# a_1236_591# DGND.t174 sky130_fd_pr__nfet_01v8 ad=0.0693 pd=0.75 as=0.0441 ps=0.63 w=0.42 l=0.15
X82 DGND.t384 a_1697_6807.t5 a_1907_6941# DGND.t383 sky130_fd_pr__nfet_01v8 ad=0.0567 pd=0.69 as=0.0567 ps=0.69 w=0.42 l=0.15
X83 a_353_2223# a_317_2455# DVDD.t591 DVDD.t590 sky130_fd_pr__pfet_01v8 ad=0.063 pd=0.72 as=0.1575 ps=1.59 w=0.42 l=0.15
X84 a_2616_6941# DGND.t585 a_2520_6575# DGND.t586 sky130_fd_pr__nfet_01v8 ad=0.0441 pd=0.63 as=0.0693 ps=0.75 w=0.42 l=0.15
X85 DGND.t719 a_1037_4625# a_1435_4765# DGND.t718 sky130_fd_pr__nfet_01v8 ad=0.0567 pd=0.69 as=0.0567 ps=0.69 w=0.42 l=0.15
X86 a_2325_1929# a_1823_3855# a_2243_1929# DVDD.t316 sky130_fd_pr__pfet_01v8 ad=0.135 pd=1.27 as=0.26 ps=2.52 w=1 l=0.15
X87 a_997_2045# a_961_1831# DVDD.t531 DVDD.t530 sky130_fd_pr__pfet_01v8 ad=0.063 pd=0.72 as=0.1575 ps=1.59 w=0.42 l=0.15
X88 a_5173_3631# b2.t1 DGND.t690 DGND.t689 sky130_fd_pr__nfet_01v8 ad=0.08775 pd=0.92 as=0.169 ps=1.82 w=0.65 l=0.15
X89 DVDD.t921 a_4268_2767# a_4575_2223# DVDD.t920 sky130_fd_pr__pfet_01v8 ad=0.0567 pd=0.69 as=0.0567 ps=0.69 w=0.42 l=0.15
X90 a_4115_5853# DVDD.t948 a_4031_5487# DGND.t765 sky130_fd_pr__nfet_01v8 ad=0.0567 pd=0.69 as=0.0567 ps=0.69 w=0.42 l=0.15
X91 a_1420_5487# DGND.t900 a_984_6183# DVDD.t37 sky130_fd_pr__pfet_01v8 ad=0.0441 pd=0.63 as=0.0693 ps=0.75 w=0.42 l=0.15
X92 a_4709_1679# DVDD.t949 DGND.t764 DGND.t763 sky130_fd_pr__nfet_01v8 ad=0.08775 pd=0.92 as=0.169 ps=1.82 w=0.65 l=0.15
X93 a_4073_4625# a0.t0 a_5541_4719# DGND.t41 sky130_fd_pr__nfet_01v8 ad=0.169 pd=1.82 as=0.08775 ps=0.92 w=0.65 l=0.15
X94 DVDD.t824 DVDD.t822 a_4379_3311# DVDD.t823 sky130_fd_pr__pfet_01v8 ad=0.0567 pd=0.69 as=0.0567 ps=0.69 w=0.42 l=0.15
X95 a_1308_2223# a_395_2344# a_1236_2223# DVDD.t510 sky130_fd_pr__pfet_01v8 ad=0.0693 pd=0.75 as=0.0441 ps=0.63 w=0.42 l=0.15
X96 a_5863_4943# a_5821_5101# a_5779_4943# DGND.t791 sky130_fd_pr__nfet_01v8 ad=0.0567 pd=0.69 as=0.0567 ps=0.69 w=0.42 l=0.15
X97 a_4073_4625# b5.t1 DVDD.t750 DVDD.t749 sky130_fd_pr__pfet_01v8 ad=0.135 pd=1.27 as=0.26 ps=2.52 w=1 l=0.15
X98 DGND.t442 a_2249_3543# a_2459_3677# DGND.t441 sky130_fd_pr__nfet_01v8 ad=0.0567 pd=0.69 as=0.0567 ps=0.69 w=0.42 l=0.15
X99 a_1251_1135# a_763_1256# DVDD.t312 DVDD.t311 sky130_fd_pr__pfet_01v8 ad=0.0567 pd=0.69 as=0.1092 ps=1.36 w=0.42 l=0.15
X100 a_6403_1679# a_5837_1831# DGND.t818 DGND.t817 sky130_fd_pr__nfet_01v8 ad=0.06195 pd=0.715 as=0.0567 ps=0.69 w=0.42 l=0.15
X101 DVDD.t414 a_4751_1831# a_4709_1929# DVDD.t413 sky130_fd_pr__pfet_01v8 ad=0.135 pd=1.27 as=0.135 ps=1.27 w=1 l=0.15
X102 a_553_1679# a_259_1831# a_469_1679# DGND.t404 sky130_fd_pr__nfet_01v8 ad=0.25025 pd=1.42 as=0.08775 ps=0.92 w=0.65 l=0.15
X103 DVDD.t79 a_2417_4625# a_2815_4399# DVDD.t78 sky130_fd_pr__pfet_01v8 ad=0.0567 pd=0.69 as=0.0567 ps=0.69 w=0.42 l=0.15
X104 a_5219_6397# a_3387_6031# DVDD.t237 DVDD.t236 sky130_fd_pr__pfet_01v8 ad=0.1092 pd=1.36 as=0.0567 ps=0.69 w=0.42 l=0.15
X105 a_5219_6031# DVDD.t950 a_5135_6031# DGND.t762 sky130_fd_pr__nfet_01v8 ad=0.0567 pd=0.69 as=0.0567 ps=0.69 w=0.42 l=0.15
X106 a_3168_3677# a_849_4105# a_3072_3311# DGND.t154 sky130_fd_pr__nfet_01v8 ad=0.0441 pd=0.63 as=0.0693 ps=0.75 w=0.42 l=0.15
X107 a_883_5309# a_317_5095# DVDD.t66 DVDD.t65 sky130_fd_pr__pfet_01v8 ad=0.06195 pd=0.715 as=0.0567 ps=0.69 w=0.42 l=0.15
X108 DVDD.t821 DVDD.t819 a_975_3311# DVDD.t820 sky130_fd_pr__pfet_01v8 ad=0.0567 pd=0.69 as=0.0567 ps=0.69 w=0.42 l=0.15
X109 a_1037_4625# b2.t2 DVDD.t513 DVDD.t512 sky130_fd_pr__pfet_01v8 ad=0.135 pd=1.27 as=0.26 ps=2.52 w=1 l=0.15
X110 a_1907_591# a_1865_749# a_485_749# DGND.t432 sky130_fd_pr__nfet_01v8 ad=0.0567 pd=0.69 as=0.0567 ps=0.69 w=0.42 l=0.15
X111 a_1604_1135# DVDD.t817 a_1508_1135# DVDD.t818 sky130_fd_pr__pfet_01v8 ad=0.0441 pd=0.63 as=0.0693 ps=0.75 w=0.42 l=0.15
X112 DGND.t816 a_5837_1831# a_6828_1679# DGND.t815 sky130_fd_pr__nfet_01v8 ad=0.1176 pd=1.4 as=0.0693 ps=0.75 w=0.42 l=0.15
X113 a_1952_2045# a_1039_1942# a_1880_2045# DVDD.t583 sky130_fd_pr__pfet_01v8 ad=0.0693 pd=0.75 as=0.0441 ps=0.63 w=0.42 l=0.15
X114 a_4103_6941# a_3537_6807# DGND.t715 DGND.t714 sky130_fd_pr__nfet_01v8 ad=0.06195 pd=0.715 as=0.0567 ps=0.69 w=0.42 l=0.15
X115 DVDD.t263 a_3663_1135# a_6173_1135# DVDD.t262 sky130_fd_pr__pfet_01v8 ad=0.26 pd=2.52 as=0.135 ps=1.27 w=1 l=0.15
X116 DVDD.t64 a_317_5095# a_1308_5309# DVDD.t63 sky130_fd_pr__pfet_01v8 ad=0.1575 pd=1.59 as=0.0693 ps=0.75 w=0.42 l=0.15
X117 DGND.t828 a_5923_1135# a_4751_1831# DGND.t827 sky130_fd_pr__nfet_01v8 ad=0.208 pd=1.94 as=0.25025 ps=1.42 w=0.65 l=0.15
X118 a_527_2589# a_395_2344# DGND.t472 DGND.t471 sky130_fd_pr__nfet_01v8 ad=0.1092 pd=1.36 as=0.0567 ps=0.69 w=0.42 l=0.15
X119 a_3941_5853# a_3905_5719# DGND.t787 DGND.t786 sky130_fd_pr__nfet_01v8 ad=0.063 pd=0.72 as=0.1596 ps=1.6 w=0.42 l=0.15
X120 a_409_3543# a5.t2 a_573_2767# DGND.t726 sky130_fd_pr__nfet_01v8 ad=0.169 pd=1.82 as=0.08775 ps=0.92 w=0.65 l=0.15
X121 a_3827_6397# a_2980_5487# DVDD.t673 DVDD.t672 sky130_fd_pr__pfet_01v8 ad=0.0567 pd=0.69 as=0.1092 ps=1.36 w=0.42 l=0.15
X122 a_3072_3311# a_2375_3311# a_2815_3311# DVDD.t498 sky130_fd_pr__pfet_01v8 ad=0.0693 pd=0.75 as=0.06195 ps=0.715 w=0.42 l=0.15
X123 a_4493_591# a_4457_743# DGND.t883 DGND.t882 sky130_fd_pr__nfet_01v8 ad=0.063 pd=0.72 as=0.1596 ps=1.6 w=0.42 l=0.15
X124 a_6756_2045# a_1823_4943# a_6412_4007# DVDD.t412 sky130_fd_pr__pfet_01v8 ad=0.0441 pd=0.63 as=0.0693 ps=0.75 w=0.42 l=0.15
X125 DGND.t713 a_3537_6807# a_4528_6941# DGND.t712 sky130_fd_pr__nfet_01v8 ad=0.1176 pd=1.4 as=0.0693 ps=0.75 w=0.42 l=0.15
X126 a_763_1256# a_1039_1942# a_997_2045# DVDD.t582 sky130_fd_pr__pfet_01v8 ad=0.0567 pd=0.69 as=0.063 ps=0.72 w=0.42 l=0.15
X127 a_2285_3677# a_2249_3543# DGND.t440 DGND.t439 sky130_fd_pr__nfet_01v8 ad=0.063 pd=0.72 as=0.1596 ps=1.6 w=0.42 l=0.15
X128 DGND.t358 a_2157_5719# a_2367_5853# DGND.t357 sky130_fd_pr__nfet_01v8 ad=0.0567 pd=0.69 as=0.0567 ps=0.69 w=0.42 l=0.15
X129 a_1775_4118# a_2235_1256# a_2193_1501# DGND.t340 sky130_fd_pr__nfet_01v8 ad=0.0567 pd=0.69 as=0.063 ps=0.72 w=0.42 l=0.15
X130 a_3076_5853# a_2325_5713# a_2980_5487# DGND.t25 sky130_fd_pr__nfet_01v8 ad=0.0441 pd=0.63 as=0.0693 ps=0.75 w=0.42 l=0.15
X131 DGND.t169 a_5188_2223# a_5923_2223# DGND.t168 sky130_fd_pr__nfet_01v8 ad=0.08775 pd=0.92 as=0.08775 ps=0.92 w=0.65 l=0.15
X132 DVDD.t108 a1.t0 a_481_6281# DVDD.t107 sky130_fd_pr__pfet_01v8 ad=0.26 pd=2.52 as=0.135 ps=1.27 w=1 l=0.15
X133 a_1907_5309# a_1823_6575# a_1823_4943# DVDD.t271 sky130_fd_pr__pfet_01v8 ad=0.0567 pd=0.69 as=0.0567 ps=0.69 w=0.42 l=0.15
X134 a_4535_854# a_5503_2767# DGND.t30 DGND.t29 sky130_fd_pr__nfet_01v8 ad=0.169 pd=1.82 as=0.169 ps=1.82 w=0.65 l=0.15
X135 DGND.t500 a_3261_6183# a_3471_6031# DGND.t499 sky130_fd_pr__nfet_01v8 ad=0.0567 pd=0.69 as=0.0567 ps=0.69 w=0.42 l=0.15
X136 DVDD.t439 a_2244_2767# a_3471_2045# DVDD.t438 sky130_fd_pr__pfet_01v8 ad=0.0567 pd=0.69 as=0.0567 ps=0.69 w=0.42 l=0.15
X137 DVDD.t549 a_3261_6183# a_4252_6397# DVDD.t548 sky130_fd_pr__pfet_01v8 ad=0.1575 pd=1.59 as=0.0693 ps=0.75 w=0.42 l=0.15
X138 a_3663_1135# a_3571_2767# a_3573_1135# DVDD.t15 sky130_fd_pr__pfet_01v8 ad=0.0567 pd=0.69 as=0.063 ps=0.72 w=0.42 l=0.15
X139 a_4847_1653# a_1775_854# a_5345_1679# DGND.t550 sky130_fd_pr__nfet_01v8 ad=0.25025 pd=1.42 as=0.08775 ps=0.92 w=0.65 l=0.15
X140 a_5873_2045# a_5837_1831# DVDD.t871 DVDD.t870 sky130_fd_pr__pfet_01v8 ad=0.063 pd=0.72 as=0.1575 ps=1.59 w=0.42 l=0.15
X141 a_2320_6031# a_481_6281# a_2248_6031# DGND.t822 sky130_fd_pr__nfet_01v8 ad=0.0693 pd=0.75 as=0.0441 ps=0.63 w=0.42 l=0.15
X142 a_4860_1367# a_5075_1148# a_5002_1174# DVDD.t149 sky130_fd_pr__pfet_01v8 ad=0.1932 pd=1.34 as=0.07665 ps=0.785 w=0.42 l=0.15
X143 a_2520_591.t0 a_485_749# a_2263_957# DVDD.t339 sky130_fd_pr__pfet_01v8 ad=0.0693 pd=0.75 as=0.06195 ps=0.715 w=0.42 l=0.15
X144 P4.t0 a_2520_6575# DGND.t631 DGND.t630 sky130_fd_pr__nfet_01v8 ad=0.169 pd=1.82 as=0.169 ps=1.82 w=0.65 l=0.15
X145 DVDD.t278 a3.t0 a_2327_4520# DVDD.t277 sky130_fd_pr__pfet_01v8 ad=0.26 pd=2.52 as=0.135 ps=1.27 w=1 l=0.15
X146 a_5311_4221# a_4031_5487# DVDD.t390 DVDD.t389 sky130_fd_pr__pfet_01v8 ad=0.1092 pd=1.36 as=0.0567 ps=0.69 w=0.42 l=0.15
X147 a_1539_6397# a_481_6281# DVDD.t877 DVDD.t876 sky130_fd_pr__pfet_01v8 ad=0.1092 pd=1.36 as=0.0567 ps=0.69 w=0.42 l=0.15
X148 a_481_6031# b1.t1 DGND.t308 DGND.t307 sky130_fd_pr__nfet_01v8 ad=0.08775 pd=0.92 as=0.169 ps=1.82 w=0.65 l=0.15
X149 DGND.t200 a_1697_743# a_2688_591# DGND.t199 sky130_fd_pr__nfet_01v8 ad=0.1176 pd=1.4 as=0.0693 ps=0.75 w=0.42 l=0.15
X150 a_2193_5853# a_2157_5719# DGND.t356 DGND.t355 sky130_fd_pr__nfet_01v8 ad=0.063 pd=0.72 as=0.1596 ps=1.6 w=0.42 l=0.15
X151 DGND.t279 a_3609_4399# a_4115_4765# DGND.t278 sky130_fd_pr__nfet_01v8 ad=0.0567 pd=0.69 as=0.0567 ps=0.69 w=0.42 l=0.15
X152 a_355_1653# a_395_2344# a_353_2223# DVDD.t509 sky130_fd_pr__pfet_01v8 ad=0.0567 pd=0.69 as=0.063 ps=0.72 w=0.42 l=0.15
X153 a_1907_4221# a_1865_4013# a_1823_3855# DVDD.t431 sky130_fd_pr__pfet_01v8 ad=0.0567 pd=0.69 as=0.0567 ps=0.69 w=0.42 l=0.15
X154 DVDD.t736 a_409_3543# a_619_3311# DVDD.t735 sky130_fd_pr__pfet_01v8 ad=0.0567 pd=0.69 as=0.0567 ps=0.69 w=0.42 l=0.15
X155 a_1457_2767# a_1421_2919# DGND.t605 DGND.t604 sky130_fd_pr__nfet_01v8 ad=0.063 pd=0.72 as=0.1596 ps=1.6 w=0.42 l=0.15
X156 a_5821_5101# a_4728_4399# DGND.t75 DGND.t74 sky130_fd_pr__nfet_01v8 ad=0.169 pd=1.82 as=0.169 ps=1.82 w=0.65 l=0.15
X157 DVDD.t330 a_573_4105# a_1987_3133# DVDD.t329 sky130_fd_pr__pfet_01v8 ad=0.0567 pd=0.69 as=0.0567 ps=0.69 w=0.42 l=0.15
X158 a_4575_2589# a_3847_3855# DGND.t798 DGND.t797 sky130_fd_pr__nfet_01v8 ad=0.1092 pd=1.36 as=0.0567 ps=0.69 w=0.42 l=0.15
X159 a_248_4631# a0.t1 a_1125_3855# DGND.t42 sky130_fd_pr__nfet_01v8 ad=0.169 pd=1.82 as=0.08775 ps=0.92 w=0.65 l=0.15
X160 a_2249_3543# a5.t3 a_3241_3855# DGND.t727 sky130_fd_pr__nfet_01v8 ad=0.169 pd=1.82 as=0.08775 ps=0.92 w=0.65 l=0.15
X161 DVDD.t110 a1.t1 a_3891_3432# DVDD.t109 sky130_fd_pr__pfet_01v8 ad=0.26 pd=2.52 as=0.135 ps=1.27 w=1 l=0.15
X162 a_3297_6031# a_3261_6183# DGND.t498 DGND.t497 sky130_fd_pr__nfet_01v8 ad=0.063 pd=0.72 as=0.1596 ps=1.6 w=0.42 l=0.15
X163 DVDD.t816 DVDD.t814 a_4471_5487# DVDD.t815 sky130_fd_pr__pfet_01v8 ad=0.0567 pd=0.69 as=0.0567 ps=0.69 w=0.42 l=0.15
X164 a_3297_2045# a_2244_2767# DVDD.t437 DVDD.t436 sky130_fd_pr__pfet_01v8 ad=0.063 pd=0.72 as=0.1575 ps=1.59 w=0.42 l=0.15
X165 a_4712_3855# a_3799_4118# a_4640_3855# DGND.t8 sky130_fd_pr__nfet_01v8 ad=0.0693 pd=0.75 as=0.0441 ps=0.63 w=0.42 l=0.15
X166 a_5075_1148# a_4625_749# DVDD.t288 DVDD.t287 sky130_fd_pr__pfet_01v8 ad=0.26 pd=2.52 as=0.26 ps=2.52 w=1 l=0.15
X167 a_2688_591# a_1775_854# a_2616_591# DGND.t549 sky130_fd_pr__nfet_01v8 ad=0.0693 pd=0.75 as=0.0441 ps=0.63 w=0.42 l=0.15
X168 DVDD.t846 a_5821_5101# a_6219_5309# DVDD.t845 sky130_fd_pr__pfet_01v8 ad=0.0567 pd=0.69 as=0.0567 ps=0.69 w=0.42 l=0.15
X169 a_1435_4399# a_757_6281# DVDD.t905 DVDD.t904 sky130_fd_pr__pfet_01v8 ad=0.06195 pd=0.715 as=0.0567 ps=0.69 w=0.42 l=0.15
X170 DGND.t465 a_2375_3311# a_4011_2767# DGND.t464 sky130_fd_pr__nfet_01v8 ad=0.0567 pd=0.69 as=0.0567 ps=0.69 w=0.42 l=0.15
X171 a_4805_2767# b4.t0 DGND.t369 DGND.t368 sky130_fd_pr__nfet_01v8 ad=0.08775 pd=0.92 as=0.169 ps=1.82 w=0.65 l=0.15
X172 a_3260_2223# a_1125_3017# a_3164_2223# DVDD.t462 sky130_fd_pr__pfet_01v8 ad=0.0441 pd=0.63 as=0.0693 ps=0.75 w=0.42 l=0.15
X173 DGND.t302 a_4544_3855# a_6368_2767# DGND.t301 sky130_fd_pr__nfet_01v8 ad=0.1176 pd=1.4 as=0.0693 ps=0.75 w=0.42 l=0.15
X174 DVDD.t257 a0.t2 a_395_5206.t0 DVDD.t256 sky130_fd_pr__pfet_01v8 ad=0.26 pd=2.52 as=0.135 ps=1.27 w=1 l=0.15
X175 DVDD.t280 a3.t1 a_2157_5719# DVDD.t279 sky130_fd_pr__pfet_01v8 ad=0.26 pd=2.52 as=0.135 ps=1.27 w=1 l=0.15
X176 a_5192_4943# a_2283_5487# a_5009_6183# DGND.t524 sky130_fd_pr__nfet_01v8 ad=0.0441 pd=0.63 as=0.0693 ps=0.75 w=0.42 l=0.15
X177 DGND.t352 a_3813_3543# a_4804_3677# DGND.t351 sky130_fd_pr__nfet_01v8 ad=0.1176 pd=1.4 as=0.0693 ps=0.75 w=0.42 l=0.15
X178 DGND.t761 DVDD.t951 a_4103_1501# DGND.t760 sky130_fd_pr__nfet_01v8 ad=0.0567 pd=0.69 as=0.0567 ps=0.69 w=0.42 l=0.15
X179 a_1823_6575# a_1775_6696# a_1733_6941# DGND.t449 sky130_fd_pr__nfet_01v8 ad=0.0567 pd=0.69 as=0.063 ps=0.72 w=0.42 l=0.15
X180 a_975_3677# a_409_3543# DGND.t707 DGND.t706 sky130_fd_pr__nfet_01v8 ad=0.06195 pd=0.715 as=0.0567 ps=0.69 w=0.42 l=0.15
X181 a_3655_2767# a_3523_3030# DGND.t138 DGND.t137 sky130_fd_pr__nfet_01v8 ad=0.1092 pd=1.36 as=0.0567 ps=0.69 w=0.42 l=0.15
X182 DGND.t256 a_1823_6575# a_2263_4943# DGND.t255 sky130_fd_pr__nfet_01v8 ad=0.0567 pd=0.69 as=0.0567 ps=0.69 w=0.42 l=0.15
X183 a_4544_3855# a_3847_3855# a_4287_4221# DVDD.t853 sky130_fd_pr__pfet_01v8 ad=0.0693 pd=0.75 as=0.06195 ps=0.715 w=0.42 l=0.15
X184 a_2616_957# a_1865_749# a_2520_591.t2 DVDD.t457 sky130_fd_pr__pfet_01v8 ad=0.0441 pd=0.63 as=0.0693 ps=0.75 w=0.42 l=0.15
X185 a_3747_1501# a_3571_2767# DGND.t15 DGND.t14 sky130_fd_pr__nfet_01v8 ad=0.1092 pd=1.36 as=0.0567 ps=0.69 w=0.42 l=0.15
X186 a_1497_6189# a0.t3 a_1861_5807# DGND.t239 sky130_fd_pr__nfet_01v8 ad=0.169 pd=1.82 as=0.08775 ps=0.92 w=0.65 l=0.15
X187 a_849_4105# b3.t1 DVDD.t190 DVDD.t189 sky130_fd_pr__pfet_01v8 ad=0.135 pd=1.27 as=0.26 ps=2.52 w=1 l=0.15
X188 a_3931_3855# a_995_4399# a_3847_3855# DGND.t131 sky130_fd_pr__nfet_01v8 ad=0.0567 pd=0.69 as=0.0567 ps=0.69 w=0.42 l=0.15
X189 a_1236_2589# DGND.t583 a_685_1367# DGND.t584 sky130_fd_pr__nfet_01v8 ad=0.0441 pd=0.63 as=0.0693 ps=0.75 w=0.42 l=0.15
X190 DGND.t705 a_409_3543# a_1400_3677# DGND.t704 sky130_fd_pr__nfet_01v8 ad=0.1176 pd=1.4 as=0.0693 ps=0.75 w=0.42 l=0.15
X191 a_5923_1135# a_3663_1135# DGND.t244 DGND.t243 sky130_fd_pr__nfet_01v8 ad=0.08775 pd=0.92 as=0.169 ps=1.82 w=0.65 l=0.15
X192 a_3655_3133# a_2375_3311# a_3571_2767# DVDD.t497 sky130_fd_pr__pfet_01v8 ad=0.0567 pd=0.69 as=0.0567 ps=0.69 w=0.42 l=0.15
X193 P8.t0 a_2520_591.t4 DGND.t853 DGND.t852 sky130_fd_pr__nfet_01v8 ad=0.169 pd=1.82 as=0.169 ps=1.82 w=0.65 l=0.15
X194 a_947_4520# b1.t2 DVDD.t332 DVDD.t331 sky130_fd_pr__pfet_01v8 ad=0.135 pd=1.27 as=0.26 ps=2.52 w=1 l=0.15
X195 a_297_3855# b5.t2 DGND.t182 DGND.t181 sky130_fd_pr__nfet_01v8 ad=0.08775 pd=0.92 as=0.169 ps=1.82 w=0.65 l=0.15
X196 a_2375_3311# a_2327_3432# a_2285_3677# DGND.t188 sky130_fd_pr__nfet_01v8 ad=0.0567 pd=0.69 as=0.063 ps=0.72 w=0.42 l=0.15
X197 DGND.t676 a_355_1653# a_219_1929# DGND.t675 sky130_fd_pr__nfet_01v8 ad=0.08775 pd=0.92 as=0.08775 ps=0.92 w=0.65 l=0.15
X198 a_4023_3311# DVDD.t812 a_3523_3030# DVDD.t813 sky130_fd_pr__pfet_01v8 ad=0.0567 pd=0.69 as=0.0567 ps=0.69 w=0.42 l=0.15
X199 a_6403_1679# a_5779_4943# DGND.t843 DGND.t842 sky130_fd_pr__nfet_01v8 ad=0.0567 pd=0.69 as=0.1092 ps=1.36 w=0.42 l=0.15
X200 a_5219_6397# DVDD.t810 a_5135_6031# DVDD.t811 sky130_fd_pr__pfet_01v8 ad=0.0567 pd=0.69 as=0.0567 ps=0.69 w=0.42 l=0.15
X201 a_3517_5487# b3.t2 DVDD.t192 DVDD.t191 sky130_fd_pr__pfet_01v8 ad=0.135 pd=1.27 as=0.26 ps=2.52 w=1 l=0.15
X202 a_1079_4765# a_947_4520# DGND.t271 DGND.t270 sky130_fd_pr__nfet_01v8 ad=0.1092 pd=1.36 as=0.0567 ps=0.69 w=0.42 l=0.15
X203 a_485_749# a_1775_854# a_1733_591# DGND.t548 sky130_fd_pr__nfet_01v8 ad=0.0567 pd=0.69 as=0.063 ps=0.72 w=0.42 l=0.15
X204 a_685_1367# a_355_1653# a_883_2223# DVDD.t708 sky130_fd_pr__pfet_01v8 ad=0.0693 pd=0.75 as=0.06195 ps=0.715 w=0.42 l=0.15
X205 a_1400_3311# a_297_3017# a_1328_3311# DVDD.t699 sky130_fd_pr__pfet_01v8 ad=0.0693 pd=0.75 as=0.0441 ps=0.63 w=0.42 l=0.15
X206 a_3517_5487# a0.t4 a_3517_5807# DGND.t685 sky130_fd_pr__nfet_01v8 ad=0.169 pd=1.82 as=0.08775 ps=0.92 w=0.65 l=0.15
X207 a_5545_2925# a_4636_3311# DVDD.t1 DVDD.t0 sky130_fd_pr__pfet_01v8 ad=0.26 pd=2.52 as=0.26 ps=2.52 w=1 l=0.15
X208 a_1784_1679# a_763_1256# a_1527_2045# DVDD.t310 sky130_fd_pr__pfet_01v8 ad=0.0693 pd=0.75 as=0.06195 ps=0.715 w=0.42 l=0.15
X209 a_4103_6941# a_627_5487# DGND.t234 DGND.t233 sky130_fd_pr__nfet_01v8 ad=0.0567 pd=0.69 as=0.1092 ps=1.36 w=0.42 l=0.15
X210 DVDD.t230 a2.t3 a_4533_2449# DVDD.t229 sky130_fd_pr__pfet_01v8 ad=0.26 pd=2.52 as=0.135 ps=1.27 w=1 l=0.15
X211 DVDD.t862 a_2980_1135# a_6005_1135# DVDD.t861 sky130_fd_pr__pfet_01v8 ad=0.135 pd=1.27 as=0.135 ps=1.27 w=1 l=0.15
X212 DGND.t810 a_219_1929# a_553_1679# DGND.t809 sky130_fd_pr__nfet_01v8 ad=0.208 pd=1.94 as=0.25025 ps=1.42 w=0.65 l=0.15
X213 a_5264_5309# a_4351_5206# a_5192_5309# DVDD.t269 sky130_fd_pr__pfet_01v8 ad=0.0693 pd=0.75 as=0.0441 ps=0.63 w=0.42 l=0.15
X214 a_2980_1135# a_1775_4118# a_2723_1501# DGND.t699 sky130_fd_pr__nfet_01v8 ad=0.0693 pd=0.75 as=0.06195 ps=0.715 w=0.42 l=0.15
X215 a_527_2589# DGND.t581 a_355_1653# DGND.t582 sky130_fd_pr__nfet_01v8 ad=0.0567 pd=0.69 as=0.0567 ps=0.69 w=0.42 l=0.15
X216 a_3148_1501# a_2235_1256# a_3076_1501# DGND.t339 sky130_fd_pr__nfet_01v8 ad=0.0693 pd=0.75 as=0.0441 ps=0.63 w=0.42 l=0.15
X217 a_4625_749# a_5779_4943# a_5873_2045# DVDD.t895 sky130_fd_pr__pfet_01v8 ad=0.0567 pd=0.69 as=0.063 ps=0.72 w=0.42 l=0.15
X218 a_1171_1679# a_1039_1942# DGND.t531 DGND.t530 sky130_fd_pr__nfet_01v8 ad=0.1092 pd=1.36 as=0.0567 ps=0.69 w=0.42 l=0.15
X219 P7.t3 a_1865_749# a_5023_591# DGND.t431 sky130_fd_pr__nfet_01v8 ad=0.0693 pd=0.75 as=0.06195 ps=0.715 w=0.42 l=0.15
X220 a_2283_5487# a_2235_5608# a_2193_5853# DGND.t506 sky130_fd_pr__nfet_01v8 ad=0.0567 pd=0.69 as=0.063 ps=0.72 w=0.42 l=0.15
X221 DVDD.t102 a_501_5719# a_711_5487# DVDD.t101 sky130_fd_pr__pfet_01v8 ad=0.0567 pd=0.69 as=0.0567 ps=0.69 w=0.42 l=0.15
X222 a_4471_4399# a_3609_4399# DVDD.t303 DVDD.t302 sky130_fd_pr__pfet_01v8 ad=0.06195 pd=0.715 as=0.0567 ps=0.69 w=0.42 l=0.15
X223 a_1039_1942# a_849_3017# a_1457_2767# DGND.t457 sky130_fd_pr__nfet_01v8 ad=0.0567 pd=0.69 as=0.063 ps=0.72 w=0.42 l=0.15
X224 P5.t3 a_1823_4943# a_2263_5309# DVDD.t411 sky130_fd_pr__pfet_01v8 ad=0.0693 pd=0.75 as=0.06195 ps=0.715 w=0.42 l=0.15
X225 a_5667_3855# a_1692_4399# DGND.t777 DGND.t776 sky130_fd_pr__nfet_01v8 ad=0.06195 pd=0.715 as=0.0567 ps=0.69 w=0.42 l=0.15
X226 a_3983_4520# b4.t1 DVDD.t393 DVDD.t392 sky130_fd_pr__pfet_01v8 ad=0.135 pd=1.27 as=0.26 ps=2.52 w=1 l=0.15
X227 a_4636_3311# a_3523_3030# a_4379_3677# DGND.t136 sky130_fd_pr__nfet_01v8 ad=0.0693 pd=0.75 as=0.06195 ps=0.715 w=0.42 l=0.15
X228 DVDD.t547 a_3261_6183# a_3471_6397# DVDD.t546 sky130_fd_pr__pfet_01v8 ad=0.0567 pd=0.69 as=0.0567 ps=0.69 w=0.42 l=0.15
X229 a_3387_6031# a_2980_5487# a_3297_6031# DGND.t635 sky130_fd_pr__nfet_01v8 ad=0.0567 pd=0.69 as=0.063 ps=0.72 w=0.42 l=0.15
X230 a_883_5309# a_395_5206.t3 DVDD.t879 DVDD.t878 sky130_fd_pr__pfet_01v8 ad=0.0567 pd=0.69 as=0.1092 ps=1.36 w=0.42 l=0.15
X231 a_4896_4765# a_3983_4520# a_4824_4765# DGND.t143 sky130_fd_pr__nfet_01v8 ad=0.0693 pd=0.75 as=0.0441 ps=0.63 w=0.42 l=0.15
X232 a_2235_1256# a_2467_2223# a_3297_2045# DVDD.t242 sky130_fd_pr__pfet_01v8 ad=0.0567 pd=0.69 as=0.063 ps=0.72 w=0.42 l=0.15
X233 P2.t0 a_984_6183# DGND.t494 DGND.t493 sky130_fd_pr__nfet_01v8 ad=0.169 pd=1.82 as=0.169 ps=1.82 w=0.65 l=0.15
X234 a_4115_4399# a_3983_4520# DVDD.t155 DVDD.t154 sky130_fd_pr__pfet_01v8 ad=0.1092 pd=1.36 as=0.0567 ps=0.69 w=0.42 l=0.15
X235 DVDD.t54 a_685_1367# a_895_1135# DVDD.t53 sky130_fd_pr__pfet_01v8 ad=0.0567 pd=0.69 as=0.0567 ps=0.69 w=0.42 l=0.15
X236 a_4180_1679# DGND.t579 a_3537_1367# DGND.t580 sky130_fd_pr__nfet_01v8 ad=0.0441 pd=0.63 as=0.0693 ps=0.75 w=0.42 l=0.15
X237 a_2320_6397# a_481_6281# a_2248_6397# DVDD.t875 sky130_fd_pr__pfet_01v8 ad=0.0693 pd=0.75 as=0.0441 ps=0.63 w=0.42 l=0.15
X238 a_6092_4221# a_4031_5487# a_6020_4221# DVDD.t388 sky130_fd_pr__pfet_01v8 ad=0.0693 pd=0.75 as=0.0441 ps=0.63 w=0.42 l=0.15
X239 DVDD.t161 a_4943_1653# a_4709_1929# DVDD.t160 sky130_fd_pr__pfet_01v8 ad=0.3 pd=2.6 as=0.165 ps=1.33 w=1 l=0.15
X240 a_2815_4765# a_2249_4631# DGND.t90 DGND.t89 sky130_fd_pr__nfet_01v8 ad=0.06195 pd=0.715 as=0.0567 ps=0.69 w=0.42 l=0.15
X241 a_1987_3133# a_849_3017# DVDD.t491 DVDD.t490 sky130_fd_pr__pfet_01v8 ad=0.0567 pd=0.69 as=0.1092 ps=1.36 w=0.42 l=0.15
X242 a_883_4943# a_317_5095# DGND.t66 DGND.t65 sky130_fd_pr__nfet_01v8 ad=0.06195 pd=0.715 as=0.0567 ps=0.69 w=0.42 l=0.15
X243 a_2520_3855# a_1823_3855# a_2263_4221# DVDD.t315 sky130_fd_pr__pfet_01v8 ad=0.0693 pd=0.75 as=0.06195 ps=0.715 w=0.42 l=0.15
X244 a_2459_3311# a_2327_3432# DVDD.t205 DVDD.t204 sky130_fd_pr__pfet_01v8 ad=0.1092 pd=1.36 as=0.0567 ps=0.69 w=0.42 l=0.15
X245 a_395_854# a_3663_1135# DGND.t242 DGND.t241 sky130_fd_pr__nfet_01v8 ad=0.169 pd=1.82 as=0.169 ps=1.82 w=0.65 l=0.15
X246 DGND.t198 a_1697_743# a_5095_1929# DGND.t197 sky130_fd_pr__nfet_01v8 ad=0.08775 pd=0.92 as=0.08775 ps=0.92 w=0.65 l=0.15
X247 a_5376_591# a_4625_749# P7.t1 DGND.t265 sky130_fd_pr__nfet_01v8 ad=0.0441 pd=0.63 as=0.0693 ps=0.75 w=0.42 l=0.15
X248 a_1907_3855# a_1775_4118# DGND.t698 DGND.t697 sky130_fd_pr__nfet_01v8 ad=0.1092 pd=1.36 as=0.0567 ps=0.69 w=0.42 l=0.15
X249 a_4575_2589# a_4533_2449# a_1775_854# DGND.t147 sky130_fd_pr__nfet_01v8 ad=0.0567 pd=0.69 as=0.0567 ps=0.69 w=0.42 l=0.15
X250 DGND.t64 a_317_5095# a_1308_4943# DGND.t63 sky130_fd_pr__nfet_01v8 ad=0.1176 pd=1.4 as=0.0693 ps=0.75 w=0.42 l=0.15
X251 a_3799_4118# a_3983_4520# a_3941_4765# DGND.t142 sky130_fd_pr__nfet_01v8 ad=0.0567 pd=0.69 as=0.063 ps=0.72 w=0.42 l=0.15
X252 a_3297_6397# a_3261_6183# DVDD.t545 DVDD.t544 sky130_fd_pr__pfet_01v8 ad=0.063 pd=0.72 as=0.1575 ps=1.59 w=0.42 l=0.15
X253 a_4103_1135# a_3537_1367# DVDD.t653 DVDD.t652 sky130_fd_pr__pfet_01v8 ad=0.06195 pd=0.715 as=0.0567 ps=0.69 w=0.42 l=0.15
X254 DVDD.t754 a5.t4 a_297_4105# DVDD.t753 sky130_fd_pr__pfet_01v8 ad=0.26 pd=2.52 as=0.135 ps=1.27 w=1 l=0.15
X255 a_2688_6941# a_1775_6696# a_2616_6941# DGND.t448 sky130_fd_pr__nfet_01v8 ad=0.0693 pd=0.75 as=0.0441 ps=0.63 w=0.42 l=0.15
X256 a_3241_6895# b0.t0 DGND.t180 DGND.t179 sky130_fd_pr__nfet_01v8 ad=0.08775 pd=0.92 as=0.169 ps=1.82 w=0.65 l=0.15
X257 DGND.t300 a_4544_3855# a_5587_2767# DGND.t299 sky130_fd_pr__nfet_01v8 ad=0.0567 pd=0.69 as=0.0567 ps=0.69 w=0.42 l=0.15
X258 a_1907_6575# a_1775_6696# DVDD.t477 DVDD.t476 sky130_fd_pr__pfet_01v8 ad=0.1092 pd=1.36 as=0.0567 ps=0.69 w=0.42 l=0.15
X259 a_6296_2767# a_5545_2925# a_5837_1831# DGND.t661 sky130_fd_pr__nfet_01v8 ad=0.0441 pd=0.63 as=0.0693 ps=0.75 w=0.42 l=0.15
X260 a_2235_5608# a2.t4 a_5265_5807# DGND.t99 sky130_fd_pr__nfet_01v8 ad=0.169 pd=1.82 as=0.08775 ps=0.92 w=0.65 l=0.15
X261 DVDD.t651 a_3537_1367# a_4528_1135# DVDD.t650 sky130_fd_pr__pfet_01v8 ad=0.1575 pd=1.59 as=0.0693 ps=0.75 w=0.42 l=0.15
X262 a_1492_5487# a_443_4943# a_1420_5487# DVDD.t715 sky130_fd_pr__pfet_01v8 ad=0.0693 pd=0.75 as=0.0441 ps=0.63 w=0.42 l=0.15
X263 a_1907_4943# a_1823_6575# a_1823_4943# DGND.t254 sky130_fd_pr__nfet_01v8 ad=0.0567 pd=0.69 as=0.0567 ps=0.69 w=0.42 l=0.15
X264 a_1328_3677# DVDD.t952 a_961_1831# DGND.t759 sky130_fd_pr__nfet_01v8 ad=0.0441 pd=0.63 as=0.0693 ps=0.75 w=0.42 l=0.15
X265 a_1697_5095.t1 a_6412_5719# DVDD.t760 DVDD.t759 sky130_fd_pr__pfet_01v8 ad=0.26 pd=2.52 as=0.26 ps=2.52 w=1 l=0.15
X266 a_409_3543# b4.t2 DVDD.t481 DVDD.t480 sky130_fd_pr__pfet_01v8 ad=0.135 pd=1.27 as=0.26 ps=2.52 w=1 l=0.15
X267 a_5863_5309# a_4399_4943# DVDD.t124 DVDD.t123 sky130_fd_pr__pfet_01v8 ad=0.1092 pd=1.36 as=0.0567 ps=0.69 w=0.42 l=0.15
X268 a_5289_1433# a_4709_1929# DVDD.t425 DVDD.t424 sky130_fd_pr__pfet_01v8 ad=0.1176 pd=1.4 as=0.0693 ps=0.75 w=0.42 l=0.15
X269 a_1676_1135# a_763_1256# a_1604_1135# DVDD.t309 sky130_fd_pr__pfet_01v8 ad=0.0693 pd=0.75 as=0.0441 ps=0.63 w=0.42 l=0.15
X270 a_5413_2767# a_4544_3855# DGND.t298 DGND.t297 sky130_fd_pr__nfet_01v8 ad=0.063 pd=0.72 as=0.1596 ps=1.6 w=0.42 l=0.15
X271 a_5023_957# a_4457_743# DVDD.t937 DVDD.t936 sky130_fd_pr__pfet_01v8 ad=0.06195 pd=0.715 as=0.0567 ps=0.69 w=0.42 l=0.15
X272 a_1079_4765# a_1037_4625# a_995_4399# DGND.t717 sky130_fd_pr__nfet_01v8 ad=0.0567 pd=0.69 as=0.0567 ps=0.69 w=0.42 l=0.15
X273 a_317_5095# a1.t2 a_573_4719# DGND.t427 sky130_fd_pr__nfet_01v8 ad=0.169 pd=1.82 as=0.08775 ps=0.92 w=0.65 l=0.15
X274 a_301_1929# a_259_1831# a_219_1929# DVDD.t429 sky130_fd_pr__pfet_01v8 ad=0.135 pd=1.27 as=0.26 ps=2.52 w=1 l=0.15
X275 a_4931_2223# a_4268_2767# DVDD.t919 DVDD.t918 sky130_fd_pr__pfet_01v8 ad=0.06195 pd=0.715 as=0.0567 ps=0.69 w=0.42 l=0.15
X276 a_2980_5487# a_2283_5487# a_2723_5853# DGND.t523 sky130_fd_pr__nfet_01v8 ad=0.0693 pd=0.75 as=0.06195 ps=0.715 w=0.42 l=0.15
X277 a_5009_6183# a_4399_4943# a_4839_5309# DVDD.t122 sky130_fd_pr__pfet_01v8 ad=0.0693 pd=0.75 as=0.06195 ps=0.715 w=0.42 l=0.15
X278 a_975_3677# a_297_3017# DGND.t667 DGND.t666 sky130_fd_pr__nfet_01v8 ad=0.0567 pd=0.69 as=0.1092 ps=1.36 w=0.42 l=0.15
X279 a_3240_4399# a_2327_4520# a_3168_4399# DVDD.t50 sky130_fd_pr__pfet_01v8 ad=0.0693 pd=0.75 as=0.0441 ps=0.63 w=0.42 l=0.15
X280 a_2907_2589# a_2045_2223# DGND.t891 DGND.t890 sky130_fd_pr__nfet_01v8 ad=0.0567 pd=0.69 as=0.1092 ps=1.36 w=0.42 l=0.15
X281 a_3148_5853# a_2235_5608# a_3076_5853# DGND.t505 sky130_fd_pr__nfet_01v8 ad=0.0693 pd=0.75 as=0.0441 ps=0.63 w=0.42 l=0.15
X282 a_2459_4399# a_2417_4625# a_2375_4399# DVDD.t77 sky130_fd_pr__pfet_01v8 ad=0.0567 pd=0.69 as=0.0567 ps=0.69 w=0.42 l=0.15
X283 DGND.t814 a_5837_1831# a_6047_1679# DGND.t813 sky130_fd_pr__nfet_01v8 ad=0.0567 pd=0.69 as=0.0567 ps=0.69 w=0.42 l=0.15
X284 DGND.t790 a_5821_5101# a_6219_4943# DGND.t789 sky130_fd_pr__nfet_01v8 ad=0.0567 pd=0.69 as=0.0567 ps=0.69 w=0.42 l=0.15
X285 a_1067_5853# a_501_5719# DGND.t98 DGND.t97 sky130_fd_pr__nfet_01v8 ad=0.06195 pd=0.715 as=0.0567 ps=0.69 w=0.42 l=0.15
X286 DGND.t785 a_3905_5719# a_4896_5853# DGND.t784 sky130_fd_pr__nfet_01v8 ad=0.1176 pd=1.4 as=0.0693 ps=0.75 w=0.42 l=0.15
X287 a_5575_6031# a_5009_6183# DGND.t629 DGND.t628 sky130_fd_pr__nfet_01v8 ad=0.06195 pd=0.715 as=0.0567 ps=0.69 w=0.42 l=0.15
X288 a_627_5487# a_443_4943# a_537_5487# DVDD.t714 sky130_fd_pr__pfet_01v8 ad=0.0567 pd=0.69 as=0.063 ps=0.72 w=0.42 l=0.15
X289 DGND.t283 a_2243_1929# P11.t1 DGND.t282 sky130_fd_pr__nfet_01v8 ad=0.208 pd=1.94 as=0.25025 ps=1.42 w=0.65 l=0.15
X290 DVDD.t917 a_4268_2767# a_5356_2223# DVDD.t916 sky130_fd_pr__pfet_01v8 ad=0.1575 pd=1.59 as=0.0693 ps=0.75 w=0.42 l=0.15
X291 a_5667_3855# a_4031_5487# DGND.t366 DGND.t365 sky130_fd_pr__nfet_01v8 ad=0.0567 pd=0.69 as=0.1092 ps=1.36 w=0.42 l=0.15
X292 a_3849_3311# a_3813_3543# DVDD.t376 DVDD.t375 sky130_fd_pr__pfet_01v8 ad=0.063 pd=0.72 as=0.1575 ps=1.59 w=0.42 l=0.15
X293 a_3471_1679# a_2467_2223# DGND.t219 DGND.t218 sky130_fd_pr__nfet_01v8 ad=0.1092 pd=1.36 as=0.0567 ps=0.69 w=0.42 l=0.15
X294 DGND.t96 a_501_5719# a_1492_5853# DGND.t95 sky130_fd_pr__nfet_01v8 ad=0.1176 pd=1.4 as=0.0693 ps=0.75 w=0.42 l=0.15
X295 a_248_4631# b0.t1 DVDD.t194 DVDD.t193 sky130_fd_pr__pfet_01v8 ad=0.135 pd=1.27 as=0.26 ps=2.52 w=1 l=0.15
X296 DVDD.t575 a_2283_5487# a_4839_5309# DVDD.t574 sky130_fd_pr__pfet_01v8 ad=0.0567 pd=0.69 as=0.0567 ps=0.69 w=0.42 l=0.15
X297 a_3387_6031# a_2980_5487# a_3297_6397# DVDD.t671 sky130_fd_pr__pfet_01v8 ad=0.0567 pd=0.69 as=0.063 ps=0.72 w=0.42 l=0.15
X298 a_4728_4399# a_3799_4118# a_4471_4765# DGND.t7 sky130_fd_pr__nfet_01v8 ad=0.0693 pd=0.75 as=0.06195 ps=0.715 w=0.42 l=0.15
X299 DGND.t758 DVDD.t953 a_2723_1501# DGND.t757 sky130_fd_pr__nfet_01v8 ad=0.0567 pd=0.69 as=0.0567 ps=0.69 w=0.42 l=0.15
X300 a_6403_2045# a_5837_1831# DVDD.t867 DVDD.t866 sky130_fd_pr__pfet_01v8 ad=0.06195 pd=0.715 as=0.0567 ps=0.69 w=0.42 l=0.15
X301 a_4115_4399# a_4073_4625# a_3799_4118# DVDD.t21 sky130_fd_pr__pfet_01v8 ad=0.0567 pd=0.69 as=0.0567 ps=0.69 w=0.42 l=0.15
X302 a_2815_4765# a_2327_4520# DGND.t50 DGND.t49 sky130_fd_pr__nfet_01v8 ad=0.0567 pd=0.69 as=0.1092 ps=1.36 w=0.42 l=0.15
X303 a_5311_3855# a_2375_4399# a_5227_3855# DGND.t421 sky130_fd_pr__nfet_01v8 ad=0.0567 pd=0.69 as=0.0567 ps=0.69 w=0.42 l=0.15
X304 DVDD.t869 a_5837_1831# a_6828_2045# DVDD.t868 sky130_fd_pr__pfet_01v8 ad=0.1575 pd=1.59 as=0.0693 ps=0.75 w=0.42 l=0.15
X305 a_849_4105# a3.t2 a_849_3855# DGND.t155 sky130_fd_pr__nfet_01v8 ad=0.169 pd=1.82 as=0.08775 ps=0.92 w=0.65 l=0.15
X306 a_2045_2223# a4.t2 a_2045_2543# DGND.t641 sky130_fd_pr__nfet_01v8 ad=0.169 pd=1.82 as=0.08775 ps=0.92 w=0.65 l=0.15
X307 a_1987_2767# a_1421_2919# DGND.t603 DGND.t602 sky130_fd_pr__nfet_01v8 ad=0.06195 pd=0.715 as=0.0567 ps=0.69 w=0.42 l=0.15
X308 a_2327_3432# a4.t3 a_2781_2767# DGND.t640 sky130_fd_pr__nfet_01v8 ad=0.169 pd=1.82 as=0.08775 ps=0.92 w=0.65 l=0.15
X309 a_895_1501# a_763_1256# DGND.t289 DGND.t288 sky130_fd_pr__nfet_01v8 ad=0.1092 pd=1.36 as=0.0567 ps=0.69 w=0.42 l=0.15
X310 a_2520_591.t1 a_485_749# a_2263_591# DGND.t315 sky130_fd_pr__nfet_01v8 ad=0.0693 pd=0.75 as=0.06195 ps=0.715 w=0.42 l=0.15
X311 a_3332_2223# a_2045_2223# a_3260_2223# DVDD.t943 sky130_fd_pr__pfet_01v8 ad=0.0693 pd=0.75 as=0.0441 ps=0.63 w=0.42 l=0.15
X312 a_3983_5608# a0.t5 a_4621_6031# DGND.t686 sky130_fd_pr__nfet_01v8 ad=0.169 pd=1.82 as=0.08775 ps=0.92 w=0.65 l=0.15
X313 a_5264_4943# a_4351_5206# a_5192_4943# DGND.t251 sky130_fd_pr__nfet_01v8 ad=0.0693 pd=0.75 as=0.0441 ps=0.63 w=0.42 l=0.15
X314 DGND.t601 a_1421_2919# a_2412_2767# DGND.t600 sky130_fd_pr__nfet_01v8 ad=0.1176 pd=1.4 as=0.0693 ps=0.75 w=0.42 l=0.15
X315 DVDD.t453 a1.t3 a_2325_5713# DVDD.t452 sky130_fd_pr__pfet_01v8 ad=0.26 pd=2.52 as=0.135 ps=1.27 w=1 l=0.15
X316 a_2249_4631# b0.t2 DVDD.t565 DVDD.t564 sky130_fd_pr__pfet_01v8 ad=0.135 pd=1.27 as=0.26 ps=2.52 w=1 l=0.15
X317 a_3891_3432# b5.t3 DVDD.t196 DVDD.t195 sky130_fd_pr__pfet_01v8 ad=0.135 pd=1.27 as=0.26 ps=2.52 w=1 l=0.15
X318 a_4103_1135# a_3571_2767# DVDD.t14 DVDD.t13 sky130_fd_pr__pfet_01v8 ad=0.0567 pd=0.69 as=0.1092 ps=1.36 w=0.42 l=0.15
X319 DVDD.t39 DGND.t901 a_883_2223# DVDD.t38 sky130_fd_pr__pfet_01v8 ad=0.0567 pd=0.69 as=0.0567 ps=0.69 w=0.42 l=0.15
X320 a_5503_2767# a_5227_3855# a_5413_2767# DGND.t73 sky130_fd_pr__nfet_01v8 ad=0.0567 pd=0.69 as=0.063 ps=0.72 w=0.42 l=0.15
X321 DGND.t88 a_2249_4631# a_3240_4765# DGND.t87 sky130_fd_pr__nfet_01v8 ad=0.1176 pd=1.4 as=0.0693 ps=0.75 w=0.42 l=0.15
X322 a_2249_4631# a4.t4 a_6277_4719# DGND.t639 sky130_fd_pr__nfet_01v8 ad=0.169 pd=1.82 as=0.08775 ps=0.92 w=0.65 l=0.15
X323 a_3941_4399# a_3609_4399# DVDD.t301 DVDD.t300 sky130_fd_pr__pfet_01v8 ad=0.063 pd=0.72 as=0.1575 ps=1.59 w=0.42 l=0.15
X324 a_984_6183# a_627_5487# a_1067_5487# DVDD.t251 sky130_fd_pr__pfet_01v8 ad=0.0693 pd=0.75 as=0.06195 ps=0.715 w=0.42 l=0.15
X325 DGND.t350 a_3813_3543# a_4023_3677# DGND.t349 sky130_fd_pr__nfet_01v8 ad=0.0567 pd=0.69 as=0.0567 ps=0.69 w=0.42 l=0.15
X326 DGND.t597 a_4860_1367# a_1865_4013# DGND.t596 sky130_fd_pr__nfet_01v8 ad=0.11285 pd=1.045 as=0.169 ps=1.82 w=0.65 l=0.15
X327 DVDD.t589 a_317_2455# a_527_2223# DVDD.t588 sky130_fd_pr__pfet_01v8 ad=0.0567 pd=0.69 as=0.0567 ps=0.69 w=0.42 l=0.15
X328 a_3261_6183# a_3517_5487# DVDD.t44 DVDD.t43 sky130_fd_pr__pfet_01v8 ad=0.26 pd=2.52 as=0.26 ps=2.52 w=1 l=0.15
X329 DVDD.t541 a_5653_5095# a_5863_5309# DVDD.t540 sky130_fd_pr__pfet_01v8 ad=0.0567 pd=0.69 as=0.0567 ps=0.69 w=0.42 l=0.15
X330 P5.t2 a_1823_4943# a_2263_4943# DGND.t389 sky130_fd_pr__nfet_01v8 ad=0.0693 pd=0.75 as=0.06195 ps=0.715 w=0.42 l=0.15
X331 DGND.t651 a_3164_2223# a_3655_2767# DGND.t650 sky130_fd_pr__nfet_01v8 ad=0.0567 pd=0.69 as=0.0567 ps=0.69 w=0.42 l=0.15
X332 a_1733_957# a_1697_743# DVDD.t218 DVDD.t217 sky130_fd_pr__pfet_01v8 ad=0.063 pd=0.72 as=0.1575 ps=1.59 w=0.42 l=0.15
X333 a_353_5309# a_317_5095# DVDD.t62 DVDD.t61 sky130_fd_pr__pfet_01v8 ad=0.063 pd=0.72 as=0.1575 ps=1.59 w=0.42 l=0.15
X334 a_883_4943# a_395_5206.t4 DGND.t108 DGND.t107 sky130_fd_pr__nfet_01v8 ad=0.0567 pd=0.69 as=0.1092 ps=1.36 w=0.42 l=0.15
X335 a_1733_3855# a_1508_1135# DGND.t126 DGND.t125 sky130_fd_pr__nfet_01v8 ad=0.063 pd=0.72 as=0.1596 ps=1.6 w=0.42 l=0.15
X336 a_317_743# a_2980_1135# DVDD.t860 DVDD.t859 sky130_fd_pr__pfet_01v8 ad=0.26 pd=2.52 as=0.26 ps=2.52 w=1 l=0.15
X337 P9.t0 a_443_591# a_883_957# DVDD.t276 sky130_fd_pr__pfet_01v8 ad=0.0693 pd=0.75 as=0.06195 ps=0.715 w=0.42 l=0.15
X338 a_2417_4625# a2.t5 a_3517_4943# DGND.t100 sky130_fd_pr__nfet_01v8 ad=0.169 pd=1.82 as=0.08775 ps=0.92 w=0.65 l=0.15
X339 DVDD.t903 a_757_6281# a_1079_4399# DVDD.t902 sky130_fd_pr__pfet_01v8 ad=0.0567 pd=0.69 as=0.0567 ps=0.69 w=0.42 l=0.15
X340 a_1457_3133# a_1421_2919# DVDD.t641 DVDD.t640 sky130_fd_pr__pfet_01v8 ad=0.063 pd=0.72 as=0.1575 ps=1.59 w=0.42 l=0.15
X341 a_5319_1174# a_443_591# a_4860_1367# DVDD.t275 sky130_fd_pr__pfet_01v8 ad=0.0441 pd=0.63 as=0.1932 ps=1.34 w=0.42 l=0.15
X342 a_2616_591# a_1865_749# a_2520_591.t3 DGND.t430 sky130_fd_pr__nfet_01v8 ad=0.0441 pd=0.63 as=0.0693 ps=0.75 w=0.42 l=0.15
X343 a_1508_1135# a_259_1831# a_1251_1135# DVDD.t428 sky130_fd_pr__pfet_01v8 ad=0.0693 pd=0.75 as=0.06195 ps=0.715 w=0.42 l=0.15
X344 a_6828_1679# a_5779_4943# a_6756_1679# DGND.t841 sky130_fd_pr__nfet_01v8 ad=0.0693 pd=0.75 as=0.0441 ps=0.63 w=0.42 l=0.15
X345 DVDD.t167 a3.t3 a_1125_3017# DVDD.t166 sky130_fd_pr__pfet_01v8 ad=0.26 pd=2.52 as=0.135 ps=1.27 w=1 l=0.15
X346 a_1733_6575# a_1697_6807.t6 DVDD.t407 DVDD.t406 sky130_fd_pr__pfet_01v8 ad=0.063 pd=0.72 as=0.1575 ps=1.59 w=0.42 l=0.15
X347 a_1308_5309# a_395_5206.t5 a_1236_5309# DVDD.t115 sky130_fd_pr__pfet_01v8 ad=0.0693 pd=0.75 as=0.0441 ps=0.63 w=0.42 l=0.15
X348 a_883_2589# a_317_2455# DGND.t539 DGND.t538 sky130_fd_pr__nfet_01v8 ad=0.06195 pd=0.715 as=0.0567 ps=0.69 w=0.42 l=0.15
X349 DGND.t130 a_995_4399# a_4287_3855# DGND.t129 sky130_fd_pr__nfet_01v8 ad=0.0567 pd=0.69 as=0.0567 ps=0.69 w=0.42 l=0.15
X350 a_3523_3030# a_3891_3432# a_3849_3311# DVDD.t911 sky130_fd_pr__pfet_01v8 ad=0.0567 pd=0.69 as=0.063 ps=0.72 w=0.42 l=0.15
X351 a_4528_6941# a_627_5487# a_4456_6941# DGND.t232 sky130_fd_pr__nfet_01v8 ad=0.0693 pd=0.75 as=0.0441 ps=0.63 w=0.42 l=0.15
X352 a_4712_4221# a_3799_4118# a_4640_4221# DVDD.t8 sky130_fd_pr__pfet_01v8 ad=0.0693 pd=0.75 as=0.0441 ps=0.63 w=0.42 l=0.15
X353 a_5689_5309# a_5653_5095# DVDD.t539 DVDD.t538 sky130_fd_pr__pfet_01v8 ad=0.063 pd=0.72 as=0.1575 ps=1.59 w=0.42 l=0.15
X354 DGND.t153 a_849_4105# a_2815_3677# DGND.t152 sky130_fd_pr__nfet_01v8 ad=0.0567 pd=0.69 as=0.0567 ps=0.69 w=0.42 l=0.15
X355 a_5289_1433# a_4709_1929# DGND.t400 DGND.t399 sky130_fd_pr__nfet_01v8 ad=0.1092 pd=1.36 as=0.1449 ps=1.11 w=0.42 l=0.15
X356 a_4471_5853# a_3983_5608# DGND.t655 DGND.t654 sky130_fd_pr__nfet_01v8 ad=0.0567 pd=0.69 as=0.1092 ps=1.36 w=0.42 l=0.15
X357 DVDD.t326 a_4544_3855# a_6368_3133# DVDD.t325 sky130_fd_pr__pfet_01v8 ad=0.1575 pd=1.59 as=0.0693 ps=0.75 w=0.42 l=0.15
X358 DGND.t537 a_317_2455# a_1308_2589# DGND.t536 sky130_fd_pr__nfet_01v8 ad=0.1176 pd=1.4 as=0.0693 ps=0.75 w=0.42 l=0.15
X359 a_3072_4399# a_2375_4399# a_2815_4399# DVDD.t444 sky130_fd_pr__pfet_01v8 ad=0.0693 pd=0.75 as=0.06195 ps=0.715 w=0.42 l=0.15
X360 DVDD.t496 a_2375_3311# a_4011_3133# DVDD.t495 sky130_fd_pr__pfet_01v8 ad=0.0567 pd=0.69 as=0.0567 ps=0.69 w=0.42 l=0.15
X361 DVDD.t314 a_1823_3855# a_2493_1929# DVDD.t313 sky130_fd_pr__pfet_01v8 ad=0.26 pd=2.52 as=0.135 ps=1.27 w=1 l=0.15
X362 a_3655_3133# a_3523_3030# DVDD.t148 DVDD.t147 sky130_fd_pr__pfet_01v8 ad=0.1092 pd=1.36 as=0.0567 ps=0.69 w=0.42 l=0.15
X363 a_527_957# a_395_854# DVDD.t185 DVDD.t184 sky130_fd_pr__pfet_01v8 ad=0.1092 pd=1.36 as=0.0567 ps=0.69 w=0.42 l=0.15
X364 a_3747_6941# DVDD.t954 a_1775_6696# DGND.t756 sky130_fd_pr__nfet_01v8 ad=0.0567 pd=0.69 as=0.0567 ps=0.69 w=0.42 l=0.15
X365 a_4824_5853# DVDD.t955 a_4351_5206# DGND.t755 sky130_fd_pr__nfet_01v8 ad=0.0441 pd=0.63 as=0.0693 ps=0.75 w=0.42 l=0.15
X366 a_3931_4221# a_995_4399# a_3847_3855# DVDD.t141 sky130_fd_pr__pfet_01v8 ad=0.0567 pd=0.69 as=0.0567 ps=0.69 w=0.42 l=0.15
X367 a_5575_6397# a_5009_6183# DVDD.t665 DVDD.t664 sky130_fd_pr__pfet_01v8 ad=0.06195 pd=0.715 as=0.0567 ps=0.69 w=0.42 l=0.15
X368 a_5575_6031# a_3387_6031# DGND.t211 DGND.t210 sky130_fd_pr__nfet_01v8 ad=0.0567 pd=0.69 as=0.1092 ps=1.36 w=0.42 l=0.15
X369 a_1067_5853# a_443_4943# DGND.t681 DGND.t680 sky130_fd_pr__nfet_01v8 ad=0.0567 pd=0.69 as=0.1092 ps=1.36 w=0.42 l=0.15
X370 DVDD.t493 a1.t4 a_3905_5719# DVDD.t492 sky130_fd_pr__pfet_01v8 ad=0.26 pd=2.52 as=0.135 ps=1.27 w=1 l=0.15
X371 a_1236_957# a_485_749# P9.t2 DVDD.t338 sky130_fd_pr__pfet_01v8 ad=0.0441 pd=0.63 as=0.0693 ps=0.75 w=0.42 l=0.15
X372 P0.t0 a_248_4631# DGND.t861 DGND.t860 sky130_fd_pr__nfet_01v8 ad=0.169 pd=1.82 as=0.169 ps=1.82 w=0.65 l=0.15
X373 a_1037_4625# a3.t4 a_1769_3631# DGND.t778 sky130_fd_pr__nfet_01v8 ad=0.169 pd=1.82 as=0.08775 ps=0.92 w=0.65 l=0.15
X374 a_4252_1679# a_2467_2223# a_4180_1679# DGND.t217 sky130_fd_pr__nfet_01v8 ad=0.0693 pd=0.75 as=0.0441 ps=0.63 w=0.42 l=0.15
X375 a_297_3017# b5.t4 DVDD.t188 DVDD.t187 sky130_fd_pr__pfet_01v8 ad=0.135 pd=1.27 as=0.26 ps=2.52 w=1 l=0.15
X376 a_2723_1135# a_1784_1679# DVDD.t355 DVDD.t354 sky130_fd_pr__pfet_01v8 ad=0.06195 pd=0.715 as=0.0567 ps=0.69 w=0.42 l=0.15
X377 a_5284_2223# a_4533_2449# a_5188_2223# DVDD.t159 sky130_fd_pr__pfet_01v8 ad=0.0441 pd=0.63 as=0.0693 ps=0.75 w=0.42 l=0.15
X378 DGND.t578 DGND.t576 a_1527_1679# DGND.t577 sky130_fd_pr__nfet_01v8 ad=0.0567 pd=0.69 as=0.0567 ps=0.69 w=0.42 l=0.15
X379 a_5928_6031# DVDD.t956 a_1697_6807.t2 DGND.t754 sky130_fd_pr__nfet_01v8 ad=0.0441 pd=0.63 as=0.0693 ps=0.75 w=0.42 l=0.15
X380 a_6403_2045# a_5779_4943# DVDD.t894 DVDD.t893 sky130_fd_pr__pfet_01v8 ad=0.0567 pd=0.69 as=0.1092 ps=1.36 w=0.42 l=0.15
X381 DGND.t613 a_2341_2455# a_2551_2589# DGND.t612 sky130_fd_pr__nfet_01v8 ad=0.0567 pd=0.69 as=0.0567 ps=0.69 w=0.42 l=0.15
X382 DGND.t24 a_2325_5713# a_2723_5853# DGND.t23 sky130_fd_pr__nfet_01v8 ad=0.0567 pd=0.69 as=0.0567 ps=0.69 w=0.42 l=0.15
X383 a_5863_4943# a_4399_4943# DGND.t118 DGND.t117 sky130_fd_pr__nfet_01v8 ad=0.1092 pd=1.36 as=0.0567 ps=0.69 w=0.42 l=0.15
X384 P10.t0 a_2520_3855# DGND.t105 DGND.t104 sky130_fd_pr__nfet_01v8 ad=0.169 pd=1.82 as=0.169 ps=1.82 w=0.65 l=0.15
X385 a_757_6281# a5.t5 a_757_6031# DGND.t728 sky130_fd_pr__nfet_01v8 ad=0.169 pd=1.82 as=0.08775 ps=0.92 w=0.65 l=0.15
X386 DVDD.t286 a_4625_749# a_5023_957# DVDD.t285 sky130_fd_pr__pfet_01v8 ad=0.0567 pd=0.69 as=0.0567 ps=0.69 w=0.42 l=0.15
X387 a_4401_2223# a_4268_2767# DVDD.t915 DVDD.t914 sky130_fd_pr__pfet_01v8 ad=0.063 pd=0.72 as=0.1575 ps=1.59 w=0.42 l=0.15
X388 a_905_4399# a_757_6281# DVDD.t901 DVDD.t900 sky130_fd_pr__pfet_01v8 ad=0.063 pd=0.72 as=0.1575 ps=1.59 w=0.42 l=0.15
X389 a_4483_5309# a_4351_5206# DVDD.t268 DVDD.t267 sky130_fd_pr__pfet_01v8 ad=0.1092 pd=1.36 as=0.0567 ps=0.69 w=0.42 l=0.15
X390 DGND.t599 a_1421_2919# a_1631_2767# DGND.t598 sky130_fd_pr__nfet_01v8 ad=0.0567 pd=0.69 as=0.0567 ps=0.69 w=0.42 l=0.15
X391 a_1171_2045# a_1039_1942# DVDD.t581 DVDD.t580 sky130_fd_pr__pfet_01v8 ad=0.1092 pd=1.36 as=0.0567 ps=0.69 w=0.42 l=0.15
X392 a_1401_6895# b0.t3 DGND.t515 DGND.t514 sky130_fd_pr__nfet_01v8 ad=0.08775 pd=0.92 as=0.169 ps=1.82 w=0.65 l=0.15
X393 a_2367_1501# a_2235_1256# DGND.t338 DGND.t337 sky130_fd_pr__nfet_01v8 ad=0.1092 pd=1.36 as=0.0567 ps=0.69 w=0.42 l=0.15
X394 a_443_4943# a_395_5206.t6 a_353_5309# DVDD.t186 sky130_fd_pr__pfet_01v8 ad=0.0567 pd=0.69 as=0.063 ps=0.72 w=0.42 l=0.15
X395 a_5009_6183# a_4399_4943# a_4839_4943# DGND.t116 sky130_fd_pr__nfet_01v8 ad=0.0693 pd=0.75 as=0.06195 ps=0.715 w=0.42 l=0.15
X396 a_445_3677# a_409_3543# DGND.t703 DGND.t702 sky130_fd_pr__nfet_01v8 ad=0.063 pd=0.72 as=0.1596 ps=1.6 w=0.42 l=0.15
X397 a_3164_2223# a_2467_2223# a_2907_2223# DVDD.t241 sky130_fd_pr__pfet_01v8 ad=0.0693 pd=0.75 as=0.06195 ps=0.715 w=0.42 l=0.15
X398 a_6368_2767# a_5227_3855# a_6296_2767# DGND.t72 sky130_fd_pr__nfet_01v8 ad=0.0693 pd=0.75 as=0.0441 ps=0.63 w=0.42 l=0.15
X399 a_4804_3677# a_3891_3432# a_4732_3677# DGND.t859 sky130_fd_pr__nfet_01v8 ad=0.0693 pd=0.75 as=0.0441 ps=0.63 w=0.42 l=0.15
X400 a_2377_2589# a_2341_2455# DGND.t611 DGND.t610 sky130_fd_pr__nfet_01v8 ad=0.063 pd=0.72 as=0.1596 ps=1.6 w=0.42 l=0.15
X401 DGND.t86 a_2249_4631# a_2459_4765# DGND.t85 sky130_fd_pr__nfet_01v8 ad=0.0567 pd=0.69 as=0.0567 ps=0.69 w=0.42 l=0.15
X402 a_1039_1942# a_849_3017# a_1457_3133# DVDD.t489 sky130_fd_pr__pfet_01v8 ad=0.0567 pd=0.69 as=0.063 ps=0.72 w=0.42 l=0.15
X403 a_3168_4765# a_2417_4625# a_3072_4399# DGND.t79 sky130_fd_pr__nfet_01v8 ad=0.0441 pd=0.63 as=0.0693 ps=0.75 w=0.42 l=0.15
X404 a_5667_4221# a_1692_4399# DVDD.t834 DVDD.t833 sky130_fd_pr__pfet_01v8 ad=0.06195 pd=0.715 as=0.0567 ps=0.69 w=0.42 l=0.15
X405 a_2340_2767# a_573_4105# a_2244_2767# DGND.t306 sky130_fd_pr__nfet_01v8 ad=0.0441 pd=0.63 as=0.0693 ps=0.75 w=0.42 l=0.15
X406 a_1895_6031# a_481_6281# DGND.t821 DGND.t820 sky130_fd_pr__nfet_01v8 ad=0.0567 pd=0.69 as=0.1092 ps=1.36 w=0.42 l=0.15
X407 a_711_5853# DGND.t574 a_627_5487# DGND.t575 sky130_fd_pr__nfet_01v8 ad=0.0567 pd=0.69 as=0.0567 ps=0.69 w=0.42 l=0.15
X408 DGND.t20 a_4073_4625# a_4471_4765# DGND.t19 sky130_fd_pr__nfet_01v8 ad=0.0567 pd=0.69 as=0.0567 ps=0.69 w=0.42 l=0.15
X409 a_5081_2767# b5.t5 DGND.t178 DGND.t177 sky130_fd_pr__nfet_01v8 ad=0.08775 pd=0.92 as=0.169 ps=1.82 w=0.65 l=0.15
X410 a_1907_5309# a_1775_5206.t2 DVDD.t479 DVDD.t478 sky130_fd_pr__pfet_01v8 ad=0.1092 pd=1.36 as=0.0567 ps=0.69 w=0.42 l=0.15
X411 a_1860_4399# a_947_4520# a_1788_4399# DVDD.t295 sky130_fd_pr__pfet_01v8 ad=0.0693 pd=0.75 as=0.0441 ps=0.63 w=0.42 l=0.15
X412 a_5137_3855# a_1692_4399# DGND.t775 DGND.t774 sky130_fd_pr__nfet_01v8 ad=0.063 pd=0.72 as=0.1596 ps=1.6 w=0.42 l=0.15
X413 a_4180_6031# a_1455_6031# a_3537_6807# DGND.t426 sky130_fd_pr__nfet_01v8 ad=0.0441 pd=0.63 as=0.0693 ps=0.75 w=0.42 l=0.15
X414 a_5779_4943# a_4399_4943# a_5689_5309# DVDD.t121 sky130_fd_pr__pfet_01v8 ad=0.0567 pd=0.69 as=0.063 ps=0.72 w=0.42 l=0.15
X415 a_4180_2045# DGND.t902 a_3537_1367# DVDD.t40 sky130_fd_pr__pfet_01v8 ad=0.0441 pd=0.63 as=0.0693 ps=0.75 w=0.42 l=0.15
X416 DVDD.t31 a_5503_2767# a_6173_2223# DVDD.t30 sky130_fd_pr__pfet_01v8 ad=0.26 pd=2.52 as=0.135 ps=1.27 w=1 l=0.15
X417 DVDD.t461 a_1125_3017# a_2907_2223# DVDD.t460 sky130_fd_pr__pfet_01v8 ad=0.0567 pd=0.69 as=0.0567 ps=0.69 w=0.42 l=0.15
X418 DGND.t522 a_2283_5487# a_4839_4943# DGND.t521 sky130_fd_pr__nfet_01v8 ad=0.0567 pd=0.69 as=0.0567 ps=0.69 w=0.42 l=0.15
X419 DGND.t281 a_5923_2223# a_4943_1653# DGND.t280 sky130_fd_pr__nfet_01v8 ad=0.208 pd=1.94 as=0.25025 ps=1.42 w=0.65 l=0.15
X420 a_573_4105# a3.t5 a_573_3855# DGND.t779 sky130_fd_pr__nfet_01v8 ad=0.169 pd=1.82 as=0.08775 ps=0.92 w=0.65 l=0.15
X421 a_5943_2767# a_4544_3855# DGND.t296 DGND.t295 sky130_fd_pr__nfet_01v8 ad=0.06195 pd=0.715 as=0.0567 ps=0.69 w=0.42 l=0.15
X422 a_895_1501# DVDD.t957 a_259_1831# DGND.t753 sky130_fd_pr__nfet_01v8 ad=0.0567 pd=0.69 as=0.0567 ps=0.69 w=0.42 l=0.15
X423 a_2285_4765# a_2249_4631# DGND.t84 DGND.t83 sky130_fd_pr__nfet_01v8 ad=0.063 pd=0.72 as=0.1596 ps=1.6 w=0.42 l=0.15
X424 a_1907_4221# a_1775_4118# DVDD.t728 DVDD.t727 sky130_fd_pr__pfet_01v8 ad=0.1092 pd=1.36 as=0.0567 ps=0.69 w=0.42 l=0.15
X425 a_6412_4007# a_4625_749# a_6403_1679# DGND.t264 sky130_fd_pr__nfet_01v8 ad=0.0693 pd=0.75 as=0.06195 ps=0.715 w=0.42 l=0.15
X426 DGND.t573 DGND.t571 a_2263_6941# DGND.t572 sky130_fd_pr__nfet_01v8 ad=0.0567 pd=0.69 as=0.0567 ps=0.69 w=0.42 l=0.15
X427 DVDD.t756 a5.t6 a_1421_2919# DVDD.t755 sky130_fd_pr__pfet_01v8 ad=0.26 pd=2.52 as=0.135 ps=1.27 w=1 l=0.15
X428 DVDD.t324 a_4544_3855# a_5587_3133# DVDD.t323 sky130_fd_pr__pfet_01v8 ad=0.0567 pd=0.69 as=0.0567 ps=0.69 w=0.42 l=0.15
X429 a_5023_591# a_4457_743# DGND.t881 DGND.t880 sky130_fd_pr__nfet_01v8 ad=0.06195 pd=0.715 as=0.0567 ps=0.69 w=0.42 l=0.15
X430 DGND.t36 a_5289_1433# a_5223_1501# DGND.t35 sky130_fd_pr__nfet_01v8 ad=0.1449 pd=1.11 as=0.0693 ps=0.75 w=0.42 l=0.15
X431 P1.t0 a_443_4943# a_883_5309# DVDD.t713 sky130_fd_pr__pfet_01v8 ad=0.0693 pd=0.75 as=0.06195 ps=0.715 w=0.42 l=0.15
X432 a_849_2767# b4.t3 DGND.t453 DGND.t452 sky130_fd_pr__nfet_01v8 ad=0.08775 pd=0.92 as=0.169 ps=1.82 w=0.65 l=0.15
X433 DVDD.t744 a_3537_6807# a_3747_6575# DVDD.t743 sky130_fd_pr__pfet_01v8 ad=0.0567 pd=0.69 as=0.0567 ps=0.69 w=0.42 l=0.15
X434 DVDD.t610 DGND.t903 a_1067_5487# DVDD.t609 sky130_fd_pr__pfet_01v8 ad=0.0567 pd=0.69 as=0.0567 ps=0.69 w=0.42 l=0.15
X435 a_1497_6189# b2.t3 DVDD.t515 DVDD.t514 sky130_fd_pr__pfet_01v8 ad=0.135 pd=1.27 as=0.26 ps=2.52 w=1 l=0.15
X436 a_3931_3855# a_3799_4118# DGND.t6 DGND.t5 sky130_fd_pr__nfet_01v8 ad=0.1092 pd=1.36 as=0.0567 ps=0.69 w=0.42 l=0.15
X437 a_6296_3133# a_5545_2925# a_5837_1831# DVDD.t693 sky130_fd_pr__pfet_01v8 ad=0.0441 pd=0.63 as=0.0693 ps=0.75 w=0.42 l=0.15
X438 DVDD.t559 a_553_1679# a_2325_1929# DVDD.t558 sky130_fd_pr__pfet_01v8 ad=0.135 pd=1.27 as=0.135 ps=1.27 w=1 l=0.15
X439 a_4456_6575# DVDD.t808 P3.t3 DVDD.t809 sky130_fd_pr__pfet_01v8 ad=0.0441 pd=0.63 as=0.0693 ps=0.75 w=0.42 l=0.15
X440 a_3905_5719# b3.t3 DVDD.t523 DVDD.t522 sky130_fd_pr__pfet_01v8 ad=0.135 pd=1.27 as=0.26 ps=2.52 w=1 l=0.15
X441 DVDD.t347 a_317_743# a_527_957# DVDD.t346 sky130_fd_pr__pfet_01v8 ad=0.0567 pd=0.69 as=0.0567 ps=0.69 w=0.42 l=0.15
X442 P3.t0 a_1775_6696# a_4103_6941# DGND.t447 sky130_fd_pr__nfet_01v8 ad=0.0693 pd=0.75 as=0.06195 ps=0.715 w=0.42 l=0.15
X443 a_2341_2455# a5.t7 a_5173_3631# DGND.t344 sky130_fd_pr__nfet_01v8 ad=0.169 pd=1.82 as=0.08775 ps=0.92 w=0.65 l=0.15
X444 DGND.t783 a_3905_5719# a_4115_5853# DGND.t782 sky130_fd_pr__nfet_01v8 ad=0.0567 pd=0.69 as=0.0567 ps=0.69 w=0.42 l=0.15
X445 a_757_6281# b0.t4 DVDD.t418 DVDD.t417 sky130_fd_pr__pfet_01v8 ad=0.135 pd=1.27 as=0.26 ps=2.52 w=1 l=0.15
X446 a_5575_6397# a_3387_6031# DVDD.t235 DVDD.t234 sky130_fd_pr__pfet_01v8 ad=0.0567 pd=0.69 as=0.1092 ps=1.36 w=0.42 l=0.15
X447 a_2327_3432# b2.t4 DVDD.t403 DVDD.t402 sky130_fd_pr__pfet_01v8 ad=0.135 pd=1.27 as=0.26 ps=2.52 w=1 l=0.15
X448 a_1775_854# a_3847_3855# a_4401_2223# DVDD.t852 sky130_fd_pr__pfet_01v8 ad=0.0567 pd=0.69 as=0.063 ps=0.72 w=0.42 l=0.15
X449 a_995_4399# a_947_4520# a_905_4399# DVDD.t294 sky130_fd_pr__pfet_01v8 ad=0.0567 pd=0.69 as=0.063 ps=0.72 w=0.42 l=0.15
X450 a_4379_3311# a_3813_3543# DVDD.t374 DVDD.t373 sky130_fd_pr__pfet_01v8 ad=0.06195 pd=0.715 as=0.0567 ps=0.69 w=0.42 l=0.15
X451 a_3537_1367# a_2235_1256# a_3827_1679# DGND.t336 sky130_fd_pr__nfet_01v8 ad=0.0693 pd=0.75 as=0.06195 ps=0.715 w=0.42 l=0.15
X452 a_2723_5487# a_2157_5719# DVDD.t384 DVDD.t383 sky130_fd_pr__pfet_01v8 ad=0.06195 pd=0.715 as=0.0567 ps=0.69 w=0.42 l=0.15
X453 DGND.t488 a_5653_5095# a_5863_4943# DGND.t487 sky130_fd_pr__nfet_01v8 ad=0.0567 pd=0.69 as=0.0567 ps=0.69 w=0.42 l=0.15
X454 a_2723_1135# a_2235_1256# DVDD.t363 DVDD.t362 sky130_fd_pr__pfet_01v8 ad=0.0567 pd=0.69 as=0.1092 ps=1.36 w=0.42 l=0.15
X455 DVDD.t807 DVDD.t805 a_1251_1135# DVDD.t806 sky130_fd_pr__pfet_01v8 ad=0.0567 pd=0.69 as=0.0567 ps=0.69 w=0.42 l=0.15
X456 a_4709_1929# a_4847_1653# DVDD.t117 DVDD.t116 sky130_fd_pr__pfet_01v8 ad=0.165 pd=1.33 as=0.135 ps=1.27 w=1 l=0.15
X457 a_2327_4520# a3.t6 a_3241_4943# DGND.t513 sky130_fd_pr__nfet_01v8 ad=0.169 pd=1.82 as=0.08775 ps=0.92 w=0.65 l=0.15
X458 a_6173_1455# a_2980_1135# DGND.t808 DGND.t807 sky130_fd_pr__nfet_01v8 ad=0.08775 pd=0.92 as=0.08775 ps=0.92 w=0.65 l=0.15
X459 a_5928_6397# DVDD.t803 a_1697_6807.t3 DVDD.t804 sky130_fd_pr__pfet_01v8 ad=0.0441 pd=0.63 as=0.0693 ps=0.75 w=0.42 l=0.15
X460 a_353_4943# a_317_5095# DGND.t62 DGND.t61 sky130_fd_pr__nfet_01v8 ad=0.063 pd=0.72 as=0.1596 ps=1.6 w=0.42 l=0.15
X461 DGND.t851 a_757_6281# a_1860_4765# DGND.t850 sky130_fd_pr__nfet_01v8 ad=0.1176 pd=1.4 as=0.0693 ps=0.75 w=0.42 l=0.15
X462 a_395_2344# a_297_3017# a_445_3677# DGND.t665 sky130_fd_pr__nfet_01v8 ad=0.0567 pd=0.69 as=0.063 ps=0.72 w=0.42 l=0.15
X463 a_5413_3133# a_4544_3855# DVDD.t322 DVDD.t321 sky130_fd_pr__pfet_01v8 ad=0.063 pd=0.72 as=0.1575 ps=1.59 w=0.42 l=0.15
X464 a_4751_1831# a_5923_1135# a_6173_1135# DVDD.t882 sky130_fd_pr__pfet_01v8 ad=0.3 pd=2.6 as=0.26 ps=2.52 w=1 l=0.15
X465 a_2341_2455# b2.t5 DVDD.t405 DVDD.t404 sky130_fd_pr__pfet_01v8 ad=0.135 pd=1.27 as=0.26 ps=2.52 w=1 l=0.15
X466 a_2467_2223# a_2045_2223# a_2377_2589# DGND.t889 sky130_fd_pr__nfet_01v8 ad=0.0567 pd=0.69 as=0.063 ps=0.72 w=0.42 l=0.15
X467 a_883_2589# a_395_2344# DGND.t470 DGND.t469 sky130_fd_pr__nfet_01v8 ad=0.0567 pd=0.69 as=0.1092 ps=1.36 w=0.42 l=0.15
X468 a_3573_6575# a_3537_6807# DVDD.t742 DVDD.t741 sky130_fd_pr__pfet_01v8 ad=0.063 pd=0.72 as=0.1575 ps=1.59 w=0.42 l=0.15
X469 a_2417_4625# b2.t6 DVDD.t717 DVDD.t191 sky130_fd_pr__pfet_01v8 ad=0.135 pd=1.27 as=0.26 ps=2.52 w=1 l=0.15
X470 a_4839_5309# a_4351_5206# DVDD.t266 DVDD.t265 sky130_fd_pr__pfet_01v8 ad=0.0567 pd=0.69 as=0.1092 ps=1.36 w=0.42 l=0.15
X471 a_3609_4399# b3.t4 DVDD.t525 DVDD.t524 sky130_fd_pr__pfet_01v8 ad=0.135 pd=1.27 as=0.26 ps=2.52 w=1 l=0.15
X472 a_4023_3311# a_3891_3432# DVDD.t910 DVDD.t909 sky130_fd_pr__pfet_01v8 ad=0.1092 pd=1.36 as=0.0567 ps=0.69 w=0.42 l=0.15
X473 a_2459_4399# a_2327_4520# DVDD.t49 DVDD.t48 sky130_fd_pr__pfet_01v8 ad=0.1092 pd=1.36 as=0.0567 ps=0.69 w=0.42 l=0.15
X474 a_1308_4943# a_395_5206.t7 a_1236_4943# DGND.t176 sky130_fd_pr__nfet_01v8 ad=0.0693 pd=0.75 as=0.0441 ps=0.63 w=0.42 l=0.15
X475 a_3609_4399# a2.t6 a_3609_4719# DGND.t101 sky130_fd_pr__nfet_01v8 ad=0.169 pd=1.82 as=0.08775 ps=0.92 w=0.65 l=0.15
X476 DGND.t570 DGND.t568 a_3827_1679# DGND.t569 sky130_fd_pr__nfet_01v8 ad=0.0567 pd=0.69 as=0.0567 ps=0.69 w=0.42 l=0.15
X477 DVDD.t353 a_1784_1679# a_3148_1135# DVDD.t352 sky130_fd_pr__pfet_01v8 ad=0.1575 pd=1.59 as=0.0693 ps=0.75 w=0.42 l=0.15
X478 a_4483_5309# a_2283_5487# a_4399_4943# DVDD.t573 sky130_fd_pr__pfet_01v8 ad=0.0567 pd=0.69 as=0.0567 ps=0.69 w=0.42 l=0.15
X479 a_5689_4943# a_5653_5095# DGND.t486 DGND.t485 sky130_fd_pr__nfet_01v8 ad=0.063 pd=0.72 as=0.1596 ps=1.6 w=0.42 l=0.15
X480 DVDD.t865 a_5837_1831# a_6047_2045# DVDD.t864 sky130_fd_pr__pfet_01v8 ad=0.0567 pd=0.69 as=0.0567 ps=0.69 w=0.42 l=0.15
X481 a_2367_5853# a_2235_5608# DGND.t504 DGND.t503 sky130_fd_pr__nfet_01v8 ad=0.1092 pd=1.36 as=0.0567 ps=0.69 w=0.42 l=0.15
X482 a_2367_1501# DVDD.t958 a_1775_4118# DGND.t752 sky130_fd_pr__nfet_01v8 ad=0.0567 pd=0.69 as=0.0567 ps=0.69 w=0.42 l=0.15
X483 a_5923_2223# a_5503_2767# DGND.t28 DGND.t27 sky130_fd_pr__nfet_01v8 ad=0.08775 pd=0.92 as=0.169 ps=1.82 w=0.65 l=0.15
X484 a_4528_1135# a_3571_2767# a_4456_1135# DVDD.t12 sky130_fd_pr__pfet_01v8 ad=0.0693 pd=0.75 as=0.0441 ps=0.63 w=0.42 l=0.15
X485 a_4457_743# a_5188_2223# DGND.t167 DGND.t166 sky130_fd_pr__nfet_01v8 ad=0.169 pd=1.82 as=0.169 ps=1.82 w=0.65 l=0.15
X486 a_2375_4399# a_2327_4520# a_2285_4765# DGND.t48 sky130_fd_pr__nfet_01v8 ad=0.0567 pd=0.69 as=0.063 ps=0.72 w=0.42 l=0.15
X487 a_5667_4221# a_4031_5487# DVDD.t387 DVDD.t386 sky130_fd_pr__pfet_01v8 ad=0.0567 pd=0.69 as=0.1092 ps=1.36 w=0.42 l=0.15
X488 a_1895_6397# a_481_6281# DVDD.t874 DVDD.t873 sky130_fd_pr__pfet_01v8 ad=0.0567 pd=0.69 as=0.1092 ps=1.36 w=0.42 l=0.15
X489 a_3471_6031# a_2980_5487# DGND.t634 DGND.t633 sky130_fd_pr__nfet_01v8 ad=0.1092 pd=1.36 as=0.0567 ps=0.69 w=0.42 l=0.15
X490 a_5045_6031# a_5009_6183# DGND.t627 DGND.t626 sky130_fd_pr__nfet_01v8 ad=0.063 pd=0.72 as=0.1596 ps=1.6 w=0.42 l=0.15
X491 a_3471_2045# a_2467_2223# DVDD.t240 DVDD.t239 sky130_fd_pr__pfet_01v8 ad=0.1092 pd=1.36 as=0.0567 ps=0.69 w=0.42 l=0.15
X492 DVDD.t299 a_3609_4399# a_4896_4399# DVDD.t298 sky130_fd_pr__pfet_01v8 ad=0.1575 pd=1.59 as=0.0693 ps=0.75 w=0.42 l=0.15
X493 a_2815_3311# a_2249_3543# DVDD.t470 DVDD.t469 sky130_fd_pr__pfet_01v8 ad=0.06195 pd=0.715 as=0.0567 ps=0.69 w=0.42 l=0.15
X494 a_3747_1135# DVDD.t801 a_3663_1135# DVDD.t802 sky130_fd_pr__pfet_01v8 ad=0.0567 pd=0.69 as=0.0567 ps=0.69 w=0.42 l=0.15
X495 a_1692_4399# a_995_4399# a_1435_4399# DVDD.t140 sky130_fd_pr__pfet_01v8 ad=0.0693 pd=0.75 as=0.06195 ps=0.715 w=0.42 l=0.15
X496 a_4180_6397# a_1455_6031# a_3537_6807# DVDD.t450 sky130_fd_pr__pfet_01v8 ad=0.0441 pd=0.63 as=0.0693 ps=0.75 w=0.42 l=0.15
X497 a_2263_3855# a_1508_1135# DGND.t124 DGND.t123 sky130_fd_pr__nfet_01v8 ad=0.06195 pd=0.715 as=0.0567 ps=0.69 w=0.42 l=0.15
X498 DVDD.t177 a_5188_2223# a_6005_2223# DVDD.t176 sky130_fd_pr__pfet_01v8 ad=0.135 pd=1.27 as=0.135 ps=1.27 w=1 l=0.15
X499 a_481_6281# a1.t5 a_481_6031# DGND.t460 sky130_fd_pr__nfet_01v8 ad=0.169 pd=1.82 as=0.08775 ps=0.92 w=0.65 l=0.15
X500 DVDD.t689 a4.t5 a_849_3017# DVDD.t688 sky130_fd_pr__pfet_01v8 ad=0.26 pd=2.52 as=0.135 ps=1.27 w=1 l=0.15
X501 DGND.t660 a_5545_2925# a_5943_2767# DGND.t659 sky130_fd_pr__nfet_01v8 ad=0.0567 pd=0.69 as=0.0567 ps=0.69 w=0.42 l=0.15
X502 a_4931_2589# a_3847_3855# DGND.t796 DGND.t795 sky130_fd_pr__nfet_01v8 ad=0.0567 pd=0.69 as=0.1092 ps=1.36 w=0.42 l=0.15
X503 a_5311_4221# a_2375_4399# a_5227_3855# DVDD.t443 sky130_fd_pr__pfet_01v8 ad=0.0567 pd=0.69 as=0.0567 ps=0.69 w=0.42 l=0.15
X504 a_961_1831# a_395_2344# a_975_3677# DGND.t468 sky130_fd_pr__nfet_01v8 ad=0.0693 pd=0.75 as=0.06195 ps=0.715 w=0.42 l=0.15
X505 a_619_3311# a_297_3017# DVDD.t698 DVDD.t697 sky130_fd_pr__pfet_01v8 ad=0.1092 pd=1.36 as=0.0567 ps=0.69 w=0.42 l=0.15
X506 DGND.t122 a_1508_1135# a_2688_3855# DGND.t121 sky130_fd_pr__nfet_01v8 ad=0.1176 pd=1.4 as=0.0693 ps=0.75 w=0.42 l=0.15
X507 a_1987_3133# a_1421_2919# DVDD.t639 DVDD.t638 sky130_fd_pr__pfet_01v8 ad=0.06195 pd=0.715 as=0.0567 ps=0.69 w=0.42 l=0.15
X508 a_2551_2223# a_2045_2223# DVDD.t942 DVDD.t941 sky130_fd_pr__pfet_01v8 ad=0.1092 pd=1.36 as=0.0567 ps=0.69 w=0.42 l=0.15
X509 a_1769_2543# b3.t5 DGND.t490 DGND.t489 sky130_fd_pr__nfet_01v8 ad=0.08775 pd=0.92 as=0.169 ps=1.82 w=0.65 l=0.15
X510 a_2263_6575# a_1697_6807.t7 DVDD.t517 DVDD.t516 sky130_fd_pr__pfet_01v8 ad=0.06195 pd=0.715 as=0.0567 ps=0.69 w=0.42 l=0.15
X511 a_297_3017# a4.t6 a_297_2767# DGND.t638 sky130_fd_pr__nfet_01v8 ad=0.169 pd=1.82 as=0.08775 ps=0.92 w=0.65 l=0.15
X512 DGND.t333 a_5095_1929# a_4847_1653# DGND.t332 sky130_fd_pr__nfet_01v8 ad=0.208 pd=1.94 as=0.25025 ps=1.42 w=0.65 l=0.15
X513 a_1125_6895# b1.t3 DGND.t310 DGND.t309 sky130_fd_pr__nfet_01v8 ad=0.08775 pd=0.92 as=0.169 ps=1.82 w=0.65 l=0.15
X514 a_2248_6031# a_1497_6189# a_501_5719# DGND.t671 sky130_fd_pr__nfet_01v8 ad=0.0441 pd=0.63 as=0.0693 ps=0.75 w=0.42 l=0.15
X515 a_4471_5487# a_3905_5719# DVDD.t842 DVDD.t841 sky130_fd_pr__pfet_01v8 ad=0.06195 pd=0.715 as=0.0567 ps=0.69 w=0.42 l=0.15
X516 a_1733_591# a_1697_743# DGND.t196 DGND.t195 sky130_fd_pr__nfet_01v8 ad=0.063 pd=0.72 as=0.1596 ps=1.6 w=0.42 l=0.15
X517 DVDD.t637 a_1421_2919# a_2412_3133# DVDD.t636 sky130_fd_pr__pfet_01v8 ad=0.1575 pd=1.59 as=0.0693 ps=0.75 w=0.42 l=0.15
X518 a_6219_5309# a_5653_5095# DVDD.t537 DVDD.t536 sky130_fd_pr__pfet_01v8 ad=0.06195 pd=0.715 as=0.0567 ps=0.69 w=0.42 l=0.15
X519 a_4483_4943# a_4351_5206# DGND.t250 DGND.t249 sky130_fd_pr__nfet_01v8 ad=0.1092 pd=1.36 as=0.0567 ps=0.69 w=0.42 l=0.15
X520 a_4011_2767# a_3523_3030# DGND.t135 DGND.t134 sky130_fd_pr__nfet_01v8 ad=0.0567 pd=0.69 as=0.1092 ps=1.36 w=0.42 l=0.15
X521 P9.t1 a_443_591# a_883_591# DGND.t258 sky130_fd_pr__nfet_01v8 ad=0.0693 pd=0.75 as=0.06195 ps=0.715 w=0.42 l=0.15
X522 DVDD.t519 a_1697_6807.t8 a_2688_6575# DVDD.t518 sky130_fd_pr__pfet_01v8 ad=0.1575 pd=1.59 as=0.0693 ps=0.75 w=0.42 l=0.15
X523 a_537_5853# a_501_5719# DGND.t94 DGND.t93 sky130_fd_pr__nfet_01v8 ad=0.063 pd=0.72 as=0.1596 ps=1.6 w=0.42 l=0.15
X524 a_2235_5608# b1.t4 DVDD.t104 DVDD.t103 sky130_fd_pr__pfet_01v8 ad=0.135 pd=1.27 as=0.26 ps=2.52 w=1 l=0.15
X525 a_4011_2767# a_3164_2223# DGND.t649 DGND.t648 sky130_fd_pr__nfet_01v8 ad=0.06195 pd=0.715 as=0.0567 ps=0.69 w=0.42 l=0.15
X526 a_3813_3543# a2.t7 a_4805_2767# DGND.t392 sky130_fd_pr__nfet_01v8 ad=0.169 pd=1.82 as=0.08775 ps=0.92 w=0.65 l=0.15
X527 a_721_1135# a_685_1367# DVDD.t52 DVDD.t51 sky130_fd_pr__pfet_01v8 ad=0.063 pd=0.72 as=0.1575 ps=1.59 w=0.42 l=0.15
X528 a_4896_5853# a_3983_5608# a_4824_5853# DGND.t653 sky130_fd_pr__nfet_01v8 ad=0.0693 pd=0.75 as=0.0441 ps=0.63 w=0.42 l=0.15
X529 a_1733_5309# a_1697_5095.t2 DVDD.t81 DVDD.t80 sky130_fd_pr__pfet_01v8 ad=0.063 pd=0.72 as=0.1575 ps=1.59 w=0.42 l=0.15
X530 a_443_4943# a_395_5206.t8 a_353_4943# DGND.t587 sky130_fd_pr__nfet_01v8 ad=0.0567 pd=0.69 as=0.063 ps=0.72 w=0.42 l=0.15
X531 a_5503_2767# a_5227_3855# a_5413_3133# DVDD.t71 sky130_fd_pr__pfet_01v8 ad=0.0567 pd=0.69 as=0.063 ps=0.72 w=0.42 l=0.15
X532 a_1907_6941# DGND.t566 a_1823_6575# DGND.t567 sky130_fd_pr__nfet_01v8 ad=0.0567 pd=0.69 as=0.0567 ps=0.69 w=0.42 l=0.15
X533 a_4115_5487# a_3983_5608# DVDD.t687 DVDD.t686 sky130_fd_pr__pfet_01v8 ad=0.1092 pd=1.36 as=0.0567 ps=0.69 w=0.42 l=0.15
X534 a_1775_6696# a_627_5487# a_3573_6575# DVDD.t250 sky130_fd_pr__pfet_01v8 ad=0.0567 pd=0.69 as=0.063 ps=0.72 w=0.42 l=0.15
X535 a_5356_2223# a_3847_3855# a_5284_2223# DVDD.t851 sky130_fd_pr__pfet_01v8 ad=0.0693 pd=0.75 as=0.0441 ps=0.63 w=0.42 l=0.15
X536 a_1365_6031# a_1329_6183# DGND.t836 DGND.t835 sky130_fd_pr__nfet_01v8 ad=0.063 pd=0.72 as=0.1596 ps=1.6 w=0.42 l=0.15
X537 DVDD.t535 a_5653_5095# a_6644_5309# DVDD.t534 sky130_fd_pr__pfet_01v8 ad=0.1575 pd=1.59 as=0.0693 ps=0.75 w=0.42 l=0.15
X538 a_1435_4765# a_947_4520# DGND.t269 DGND.t268 sky130_fd_pr__nfet_01v8 ad=0.0567 pd=0.69 as=0.1092 ps=1.36 w=0.42 l=0.15
X539 DVDD.t681 a_3164_2223# a_3655_3133# DVDD.t680 sky130_fd_pr__pfet_01v8 ad=0.0567 pd=0.69 as=0.0567 ps=0.69 w=0.42 l=0.15
X540 a_1907_4943# a_1775_5206.t3 DGND.t541 DGND.t540 sky130_fd_pr__nfet_01v8 ad=0.1092 pd=1.36 as=0.0567 ps=0.69 w=0.42 l=0.15
X541 a_1733_4221# a_1508_1135# DVDD.t132 DVDD.t131 sky130_fd_pr__pfet_01v8 ad=0.063 pd=0.72 as=0.1575 ps=1.59 w=0.42 l=0.15
X542 a_3240_3677# a_2327_3432# a_3168_3677# DGND.t187 sky130_fd_pr__nfet_01v8 ad=0.0693 pd=0.75 as=0.0441 ps=0.63 w=0.42 l=0.15
X543 a_4379_3311# a_3891_3432# DVDD.t908 DVDD.t907 sky130_fd_pr__pfet_01v8 ad=0.0567 pd=0.69 as=0.1092 ps=1.36 w=0.42 l=0.15
X544 DGND.t647 a_3164_2223# a_4436_2767# DGND.t646 sky130_fd_pr__nfet_01v8 ad=0.1176 pd=1.4 as=0.0693 ps=0.75 w=0.42 l=0.15
X545 a_1907_957# a_1775_854# DVDD.t606 DVDD.t605 sky130_fd_pr__pfet_01v8 ad=0.1092 pd=1.36 as=0.0567 ps=0.69 w=0.42 l=0.15
X546 a_2723_5487# a_2235_5608# DVDD.t557 DVDD.t556 sky130_fd_pr__pfet_01v8 ad=0.0567 pd=0.69 as=0.1092 ps=1.36 w=0.42 l=0.15
X547 DVDD.t318 a4.t7 a_947_4520# DVDD.t317 sky130_fd_pr__pfet_01v8 ad=0.26 pd=2.52 as=0.135 ps=1.27 w=1 l=0.15
X548 a_2459_3677# a_849_4105# a_2375_3311# DGND.t151 sky130_fd_pr__nfet_01v8 ad=0.0567 pd=0.69 as=0.0567 ps=0.69 w=0.42 l=0.15
X549 a_469_1679# a_355_1653# DGND.t674 DGND.t673 sky130_fd_pr__nfet_01v8 ad=0.08775 pd=0.92 as=0.08775 ps=0.92 w=0.65 l=0.15
X550 a_5779_4943# a_4399_4943# a_5689_4943# DGND.t115 sky130_fd_pr__nfet_01v8 ad=0.0567 pd=0.69 as=0.063 ps=0.72 w=0.42 l=0.15
X551 DGND.t388 a_1823_4943# a_6403_1679# DGND.t387 sky130_fd_pr__nfet_01v8 ad=0.0567 pd=0.69 as=0.0567 ps=0.69 w=0.42 l=0.15
X552 a_4709_1929# DVDD.t798 DVDD.t800 DVDD.t799 sky130_fd_pr__pfet_01v8 ad=0.135 pd=1.27 as=0.26 ps=2.52 w=1 l=0.15
X553 a_4031_5487# a_3983_5608# a_3941_5853# DGND.t652 sky130_fd_pr__nfet_01v8 ad=0.0567 pd=0.69 as=0.063 ps=0.72 w=0.42 l=0.15
X554 a_1788_4765# a_1037_4625# a_1692_4399# DGND.t716 sky130_fd_pr__nfet_01v8 ad=0.0441 pd=0.63 as=0.0693 ps=0.75 w=0.42 l=0.15
X555 a_317_5095# b0.t5 DVDD.t419 DVDD.t168 sky130_fd_pr__pfet_01v8 ad=0.135 pd=1.27 as=0.26 ps=2.52 w=1 l=0.15
X556 a_527_591# a_395_854# DGND.t173 DGND.t172 sky130_fd_pr__nfet_01v8 ad=0.1092 pd=1.36 as=0.0567 ps=0.69 w=0.42 l=0.15
X557 a_6828_2045# a_5779_4943# a_6756_2045# DVDD.t892 sky130_fd_pr__pfet_01v8 ad=0.0693 pd=0.75 as=0.0441 ps=0.63 w=0.42 l=0.15
X558 a_5541_4719# b5.t6 DGND.t157 DGND.t156 sky130_fd_pr__nfet_01v8 ad=0.08775 pd=0.92 as=0.169 ps=1.82 w=0.65 l=0.15
X559 DVDD.t427 a_259_1831# a_469_1929# DVDD.t426 sky130_fd_pr__pfet_01v8 ad=0.26 pd=2.52 as=0.135 ps=1.27 w=1 l=0.15
X560 a_6005_1135# a_3663_1135# a_5923_1135# DVDD.t261 sky130_fd_pr__pfet_01v8 ad=0.135 pd=1.27 as=0.26 ps=2.52 w=1 l=0.15
X561 a_1236_591# a_485_749# P9.t3 DGND.t314 sky130_fd_pr__nfet_01v8 ad=0.0441 pd=0.63 as=0.0693 ps=0.75 w=0.42 l=0.15
X562 a_3757_3855# a_3072_3311# DGND.t595 DGND.t594 sky130_fd_pr__nfet_01v8 ad=0.063 pd=0.72 as=0.1596 ps=1.6 w=0.42 l=0.15
X563 DGND.t751 DVDD.t959 a_4103_6941# DGND.t750 sky130_fd_pr__nfet_01v8 ad=0.0567 pd=0.69 as=0.0567 ps=0.69 w=0.42 l=0.15
X564 DVDD.t139 a_995_4399# a_4287_4221# DVDD.t138 sky130_fd_pr__pfet_01v8 ad=0.0567 pd=0.69 as=0.0567 ps=0.69 w=0.42 l=0.15
X565 P8.t1 a_2520_591.t5 DVDD.t571 DVDD.t570 sky130_fd_pr__pfet_01v8 ad=0.26 pd=2.52 as=0.26 ps=2.52 w=1 l=0.15
X566 a_5135_6031# a_3387_6031# a_5045_6031# DGND.t209 sky130_fd_pr__nfet_01v8 ad=0.0567 pd=0.69 as=0.063 ps=0.72 w=0.42 l=0.15
X567 P6.t0 a_6412_4007# DGND.t396 DGND.t395 sky130_fd_pr__nfet_01v8 ad=0.169 pd=1.82 as=0.169 ps=1.82 w=0.65 l=0.15
X568 a_4732_3311# DVDD.t796 a_4636_3311# DVDD.t797 sky130_fd_pr__pfet_01v8 ad=0.0441 pd=0.63 as=0.0693 ps=0.75 w=0.42 l=0.15
X569 DVDD.t351 a_1784_1679# a_2367_1135# DVDD.t350 sky130_fd_pr__pfet_01v8 ad=0.0567 pd=0.69 as=0.0567 ps=0.69 w=0.42 l=0.15
X570 a_3747_6941# a_627_5487# DGND.t231 DGND.t230 sky130_fd_pr__nfet_01v8 ad=0.1092 pd=1.36 as=0.0567 ps=0.69 w=0.42 l=0.15
X571 DVDD.t382 a_2157_5719# a_3148_5487# DVDD.t381 sky130_fd_pr__pfet_01v8 ad=0.1575 pd=1.59 as=0.0693 ps=0.75 w=0.42 l=0.15
X572 a_3076_1135# DVDD.t794 a_2980_1135# DVDD.t795 sky130_fd_pr__pfet_01v8 ad=0.0441 pd=0.63 as=0.0693 ps=0.75 w=0.42 l=0.15
X573 a_1171_1679# DGND.t564 a_763_1256# DGND.t565 sky130_fd_pr__nfet_01v8 ad=0.0567 pd=0.69 as=0.0567 ps=0.69 w=0.42 l=0.15
X574 DGND.t263 a_4625_749# a_5023_591# DGND.t262 sky130_fd_pr__nfet_01v8 ad=0.0567 pd=0.69 as=0.0567 ps=0.69 w=0.42 l=0.15
X575 a_2367_5853# a_2325_5713# a_2283_5487# DGND.t22 sky130_fd_pr__nfet_01v8 ad=0.0567 pd=0.69 as=0.0567 ps=0.69 w=0.42 l=0.15
X576 a_711_5487# a_443_4943# DVDD.t712 DVDD.t711 sky130_fd_pr__pfet_01v8 ad=0.1092 pd=1.36 as=0.0567 ps=0.69 w=0.42 l=0.15
X577 P1.t1 a_443_4943# a_883_4943# DGND.t679 sky130_fd_pr__nfet_01v8 ad=0.0693 pd=0.75 as=0.06195 ps=0.715 w=0.42 l=0.15
X578 a_573_4105# b5.t7 DVDD.t169 DVDD.t168 sky130_fd_pr__pfet_01v8 ad=0.135 pd=1.27 as=0.26 ps=2.52 w=1 l=0.15
X579 a_2907_2589# a_2341_2455# DGND.t609 DGND.t608 sky130_fd_pr__nfet_01v8 ad=0.06195 pd=0.715 as=0.0567 ps=0.69 w=0.42 l=0.15
X580 a_1125_2767# b4.t4 DGND.t159 DGND.t158 sky130_fd_pr__nfet_01v8 ad=0.08775 pd=0.92 as=0.169 ps=1.82 w=0.65 l=0.15
X581 a_527_957# a_485_749# a_443_591# DVDD.t337 sky130_fd_pr__pfet_01v8 ad=0.0567 pd=0.69 as=0.0567 ps=0.69 w=0.42 l=0.15
X582 a_4252_6031# a_2980_5487# a_4180_6031# DGND.t632 sky130_fd_pr__nfet_01v8 ad=0.0693 pd=0.75 as=0.0441 ps=0.63 w=0.42 l=0.15
X583 a_4471_4399# a_3983_4520# DVDD.t153 DVDD.t152 sky130_fd_pr__pfet_01v8 ad=0.0567 pd=0.69 as=0.1092 ps=1.36 w=0.42 l=0.15
X584 a_1251_1501# a_685_1367# DGND.t56 DGND.t55 sky130_fd_pr__nfet_01v8 ad=0.06195 pd=0.715 as=0.0567 ps=0.69 w=0.42 l=0.15
X585 a_4252_2045# a_2467_2223# a_4180_2045# DVDD.t238 sky130_fd_pr__pfet_01v8 ad=0.0693 pd=0.75 as=0.0441 ps=0.63 w=0.42 l=0.15
X586 DVDD.t399 a1.t6 a_3983_4520# DVDD.t398 sky130_fd_pr__pfet_01v8 ad=0.26 pd=2.52 as=0.135 ps=1.27 w=1 l=0.15
X587 DGND.t607 a_2341_2455# a_3332_2589# DGND.t606 sky130_fd_pr__nfet_01v8 ad=0.1176 pd=1.4 as=0.0693 ps=0.75 w=0.42 l=0.15
X588 a_3471_6397# a_2980_5487# DVDD.t670 DVDD.t669 sky130_fd_pr__pfet_01v8 ad=0.1092 pd=1.36 as=0.0567 ps=0.69 w=0.42 l=0.15
X589 a_5045_6397# a_5009_6183# DVDD.t663 DVDD.t662 sky130_fd_pr__pfet_01v8 ad=0.063 pd=0.72 as=0.1575 ps=1.59 w=0.42 l=0.15
X590 DVDD.t793 DVDD.t791 a_883_5309# DVDD.t792 sky130_fd_pr__pfet_01v8 ad=0.0567 pd=0.69 as=0.0567 ps=0.69 w=0.42 l=0.15
X591 a_1697_743# a_3663_1135# a_4103_1135# DVDD.t260 sky130_fd_pr__pfet_01v8 ad=0.0693 pd=0.75 as=0.06195 ps=0.715 w=0.42 l=0.15
X592 a_4824_4399# a_4073_4625# a_4728_4399# DVDD.t20 sky130_fd_pr__pfet_01v8 ad=0.0441 pd=0.63 as=0.0693 ps=0.75 w=0.42 l=0.15
X593 a_2815_3311# a_2327_3432# DVDD.t203 DVDD.t202 sky130_fd_pr__pfet_01v8 ad=0.0567 pd=0.69 as=0.1092 ps=1.36 w=0.42 l=0.15
X594 a_2193_1135# a_1784_1679# DVDD.t349 DVDD.t348 sky130_fd_pr__pfet_01v8 ad=0.063 pd=0.72 as=0.1575 ps=1.59 w=0.42 l=0.15
X595 DVDD.t612 DGND.t904 a_1527_2045# DVDD.t611 sky130_fd_pr__pfet_01v8 ad=0.0567 pd=0.69 as=0.0567 ps=0.69 w=0.42 l=0.15
X596 a_2263_3855# a_1775_4118# DGND.t696 DGND.t695 sky130_fd_pr__nfet_01v8 ad=0.0567 pd=0.69 as=0.1092 ps=1.36 w=0.42 l=0.15
X597 a_6020_3855# a_2375_4399# a_5653_5095# DGND.t420 sky130_fd_pr__nfet_01v8 ad=0.0441 pd=0.63 as=0.0693 ps=0.75 w=0.42 l=0.15
X598 a_883_957# a_317_743# DVDD.t345 DVDD.t344 sky130_fd_pr__pfet_01v8 ad=0.06195 pd=0.715 as=0.0567 ps=0.69 w=0.42 l=0.15
X599 a_259_1831# a_763_1256# a_721_1135# DVDD.t308 sky130_fd_pr__pfet_01v8 ad=0.0567 pd=0.69 as=0.063 ps=0.72 w=0.42 l=0.15
X600 DGND.t773 a_1692_4399# a_6092_3855# DGND.t772 sky130_fd_pr__nfet_01v8 ad=0.1176 pd=1.4 as=0.0693 ps=0.75 w=0.42 l=0.15
X601 DVDD.t604 a_1775_854# a_5345_1929# DVDD.t603 sky130_fd_pr__pfet_01v8 ad=0.26 pd=2.52 as=0.135 ps=1.27 w=1 l=0.15
X602 a_5345_1679# a_1697_743# DGND.t194 DGND.t193 sky130_fd_pr__nfet_01v8 ad=0.08775 pd=0.92 as=0.08775 ps=0.92 w=0.65 l=0.15
X603 a_353_2589# a_317_2455# DGND.t535 DGND.t534 sky130_fd_pr__nfet_01v8 ad=0.063 pd=0.72 as=0.1596 ps=1.6 w=0.42 l=0.15
X604 DVDD.t60 a_317_5095# a_527_5309# DVDD.t59 sky130_fd_pr__pfet_01v8 ad=0.0567 pd=0.69 as=0.0567 ps=0.69 w=0.42 l=0.15
X605 DGND.t120 a_1508_1135# a_1907_3855# DGND.t119 sky130_fd_pr__nfet_01v8 ad=0.0567 pd=0.69 as=0.0567 ps=0.69 w=0.42 l=0.15
X606 a_619_3311# DVDD.t789 a_395_2344# DVDD.t790 sky130_fd_pr__pfet_01v8 ad=0.0567 pd=0.69 as=0.0567 ps=0.69 w=0.42 l=0.15
X607 DGND.t54 a_685_1367# a_1676_1501# DGND.t53 sky130_fd_pr__nfet_01v8 ad=0.1176 pd=1.4 as=0.0693 ps=0.75 w=0.42 l=0.15
X608 a_2327_4520# b1.t5 DVDD.t106 DVDD.t105 sky130_fd_pr__pfet_01v8 ad=0.135 pd=1.27 as=0.26 ps=2.52 w=1 l=0.15
X609 a_4839_4943# a_4351_5206# DGND.t248 DGND.t247 sky130_fd_pr__nfet_01v8 ad=0.0567 pd=0.69 as=0.1092 ps=1.36 w=0.42 l=0.15
X610 a_2616_3855# a_1865_4013# a_2520_3855# DGND.t408 sky130_fd_pr__nfet_01v8 ad=0.0441 pd=0.63 as=0.0693 ps=0.75 w=0.42 l=0.15
X611 a_1455_6031# a_481_6281# a_1365_6031# DGND.t819 sky130_fd_pr__nfet_01v8 ad=0.0567 pd=0.69 as=0.063 ps=0.72 w=0.42 l=0.15
X612 DGND.t869 a_4268_2767# a_4575_2589# DGND.t868 sky130_fd_pr__nfet_01v8 ad=0.0567 pd=0.69 as=0.0567 ps=0.69 w=0.42 l=0.15
X613 a_2263_6575# a_1775_6696# DVDD.t475 DVDD.t474 sky130_fd_pr__pfet_01v8 ad=0.0567 pd=0.69 as=0.1092 ps=1.36 w=0.42 l=0.15
X614 DVDD.t635 a_1421_2919# a_1631_3133# DVDD.t634 sky130_fd_pr__pfet_01v8 ad=0.0567 pd=0.69 as=0.0567 ps=0.69 w=0.42 l=0.15
X615 a_2248_6397# a_1497_6189# a_501_5719# DVDD.t703 sky130_fd_pr__pfet_01v8 ad=0.0441 pd=0.63 as=0.0693 ps=0.75 w=0.42 l=0.15
X616 DVDD.t521 a_1697_6807.t9 a_1907_6575# DVDD.t520 sky130_fd_pr__pfet_01v8 ad=0.0567 pd=0.69 as=0.0567 ps=0.69 w=0.42 l=0.15
X617 DGND.t749 DVDD.t960 a_4379_3677# DGND.t748 sky130_fd_pr__nfet_01v8 ad=0.0567 pd=0.69 as=0.0567 ps=0.69 w=0.42 l=0.15
X618 DVDD.t468 a_2249_3543# a_3240_3311# DVDD.t467 sky130_fd_pr__pfet_01v8 ad=0.1575 pd=1.59 as=0.0693 ps=0.75 w=0.42 l=0.15
X619 a_6368_3133# a_5227_3855# a_6296_3133# DVDD.t70 sky130_fd_pr__pfet_01v8 ad=0.0693 pd=0.75 as=0.0441 ps=0.63 w=0.42 l=0.15
X620 a_1308_2589# a_395_2344# a_1236_2589# DGND.t467 sky130_fd_pr__nfet_01v8 ad=0.0693 pd=0.75 as=0.0441 ps=0.63 w=0.42 l=0.15
X621 a_4483_4943# a_2283_5487# a_4399_4943# DGND.t520 sky130_fd_pr__nfet_01v8 ad=0.0567 pd=0.69 as=0.0567 ps=0.69 w=0.42 l=0.15
X622 a_5587_2767# a_5227_3855# DGND.t71 DGND.t70 sky130_fd_pr__nfet_01v8 ad=0.1092 pd=1.36 as=0.0567 ps=0.69 w=0.42 l=0.15
X623 a_2551_2223# a_1125_3017# a_2467_2223# DVDD.t459 sky130_fd_pr__pfet_01v8 ad=0.0567 pd=0.69 as=0.0567 ps=0.69 w=0.42 l=0.15
X624 a_2616_6575# DGND.t905 a_2520_6575# DVDD.t613 sky130_fd_pr__pfet_01v8 ad=0.0441 pd=0.63 as=0.0693 ps=0.75 w=0.42 l=0.15
X625 a_6219_5309# a_4399_4943# DVDD.t120 DVDD.t119 sky130_fd_pr__pfet_01v8 ad=0.0567 pd=0.69 as=0.1092 ps=1.36 w=0.42 l=0.15
X626 DVDD.t748 a_1037_4625# a_1435_4399# DVDD.t747 sky130_fd_pr__pfet_01v8 ad=0.0567 pd=0.69 as=0.0567 ps=0.69 w=0.42 l=0.15
X627 a_3241_3855# b1.t6 DGND.t103 DGND.t102 sky130_fd_pr__nfet_01v8 ad=0.08775 pd=0.92 as=0.169 ps=1.82 w=0.65 l=0.15
X628 a_2520_6575# a_1823_6575# a_2263_6941# DGND.t253 sky130_fd_pr__nfet_01v8 ad=0.0693 pd=0.75 as=0.06195 ps=0.715 w=0.42 l=0.15
X629 a_4351_5206# a_4031_5487# a_4471_5853# DGND.t364 sky130_fd_pr__nfet_01v8 ad=0.0693 pd=0.75 as=0.06195 ps=0.715 w=0.42 l=0.15
X630 a_2340_3133# a_573_4105# a_2244_2767# DVDD.t328 sky130_fd_pr__pfet_01v8 ad=0.0441 pd=0.63 as=0.0693 ps=0.75 w=0.42 l=0.15
X631 a_4115_5487# DVDD.t787 a_4031_5487# DVDD.t788 sky130_fd_pr__pfet_01v8 ad=0.0567 pd=0.69 as=0.0567 ps=0.69 w=0.42 l=0.15
X632 DGND.t747 DVDD.t961 a_975_3677# DGND.t746 sky130_fd_pr__nfet_01v8 ad=0.0567 pd=0.69 as=0.0567 ps=0.69 w=0.42 l=0.15
X633 a_3847_3855# a_3799_4118# a_3757_3855# DGND.t4 sky130_fd_pr__nfet_01v8 ad=0.0567 pd=0.69 as=0.063 ps=0.72 w=0.42 l=0.15
X634 DVDD.t336 a_485_749# a_883_957# DVDD.t335 sky130_fd_pr__pfet_01v8 ad=0.0567 pd=0.69 as=0.0567 ps=0.69 w=0.42 l=0.15
X635 a_5188_2223# a_1775_854# a_4931_2223# DVDD.t602 sky130_fd_pr__pfet_01v8 ad=0.0693 pd=0.75 as=0.06195 ps=0.715 w=0.42 l=0.15
X636 a_5137_4221# a_1692_4399# DVDD.t832 DVDD.t831 sky130_fd_pr__pfet_01v8 ad=0.063 pd=0.72 as=0.1575 ps=1.59 w=0.42 l=0.15
X637 a_2157_5719# b0.t6 DVDD.t721 DVDD.t720 sky130_fd_pr__pfet_01v8 ad=0.135 pd=1.27 as=0.26 ps=2.52 w=1 l=0.15
X638 a_1365_6397# a_1329_6183# DVDD.t890 DVDD.t889 sky130_fd_pr__pfet_01v8 ad=0.063 pd=0.72 as=0.1575 ps=1.59 w=0.42 l=0.15
X639 DVDD.t366 a5.t8 a_409_3543# DVDD.t365 sky130_fd_pr__pfet_01v8 ad=0.26 pd=2.52 as=0.135 ps=1.27 w=1 l=0.15
X640 DGND.t621 a_3537_1367# a_3747_1501# DGND.t620 sky130_fd_pr__nfet_01v8 ad=0.0567 pd=0.69 as=0.0567 ps=0.69 w=0.42 l=0.15
X641 a_6572_5309# a_5821_5101# a_6412_5719# DVDD.t844 sky130_fd_pr__pfet_01v8 ad=0.0441 pd=0.63 as=0.0693 ps=0.75 w=0.42 l=0.15
X642 a_3072_3311# a_2375_3311# a_2815_3677# DGND.t463 sky130_fd_pr__nfet_01v8 ad=0.0693 pd=0.75 as=0.06195 ps=0.715 w=0.42 l=0.15
X643 a_4364_2767# a_2375_3311# a_4268_2767# DGND.t462 sky130_fd_pr__nfet_01v8 ad=0.0441 pd=0.63 as=0.0693 ps=0.75 w=0.42 l=0.15
X644 a_4456_1501# DVDD.t962 a_1697_743# DGND.t745 sky130_fd_pr__nfet_01v8 ad=0.0441 pd=0.63 as=0.0693 ps=0.75 w=0.42 l=0.15
X645 a_5943_3133# a_4544_3855# DVDD.t320 DVDD.t319 sky130_fd_pr__pfet_01v8 ad=0.06195 pd=0.715 as=0.0567 ps=0.69 w=0.42 l=0.15
X646 DGND.t319 a_317_743# a_527_591# DGND.t318 sky130_fd_pr__nfet_01v8 ad=0.0567 pd=0.69 as=0.0567 ps=0.69 w=0.42 l=0.15
X647 a_1697_6807.t0 a_5135_6031# a_5575_6031# DGND.t32 sky130_fd_pr__nfet_01v8 ad=0.0693 pd=0.75 as=0.06195 ps=0.715 w=0.42 l=0.15
X648 a_4103_6575# a_3537_6807# DVDD.t740 DVDD.t739 sky130_fd_pr__pfet_01v8 ad=0.06195 pd=0.715 as=0.0567 ps=0.69 w=0.42 l=0.15
X649 DVDD.t707 a_355_1653# a_301_1929# DVDD.t706 sky130_fd_pr__pfet_01v8 ad=0.135 pd=1.27 as=0.135 ps=1.27 w=1 l=0.15
X650 DVDD.t158 a_4533_2449# a_4931_2223# DVDD.t157 sky130_fd_pr__pfet_01v8 ad=0.0567 pd=0.69 as=0.0567 ps=0.69 w=0.42 l=0.15
X651 a_3517_5807# b3.t6 DGND.t492 DGND.t491 sky130_fd_pr__nfet_01v8 ad=0.08775 pd=0.92 as=0.169 ps=1.82 w=0.65 l=0.15
X652 a_3941_5487# a_3905_5719# DVDD.t840 DVDD.t839 sky130_fd_pr__pfet_01v8 ad=0.063 pd=0.72 as=0.1575 ps=1.59 w=0.42 l=0.15
X653 a_4535_854# a_5503_2767# DVDD.t29 DVDD.t28 sky130_fd_pr__pfet_01v8 ad=0.26 pd=2.52 as=0.26 ps=2.52 w=1 l=0.15
X654 a_317_2455# a_297_4105# DGND.t730 DGND.t729 sky130_fd_pr__nfet_01v8 ad=0.169 pd=1.82 as=0.169 ps=1.82 w=0.65 l=0.15
X655 a_6412_4007# a_4625_749# a_6403_2045# DVDD.t284 sky130_fd_pr__pfet_01v8 ad=0.0693 pd=0.75 as=0.06195 ps=0.715 w=0.42 l=0.15
X656 DVDD.t738 a_3537_6807# a_4528_6575# DVDD.t737 sky130_fd_pr__pfet_01v8 ad=0.1575 pd=1.59 as=0.0693 ps=0.75 w=0.42 l=0.15
X657 a_5135_6031# a_3387_6031# a_5045_6397# DVDD.t233 sky130_fd_pr__pfet_01v8 ad=0.0567 pd=0.69 as=0.063 ps=0.72 w=0.42 l=0.15
X658 a_2493_1679# a_553_1679# DGND.t512 DGND.t511 sky130_fd_pr__nfet_01v8 ad=0.08775 pd=0.92 as=0.08775 ps=0.92 w=0.65 l=0.15
X659 DVDD.t380 a_2157_5719# a_2367_5487# DVDD.t379 sky130_fd_pr__pfet_01v8 ad=0.0567 pd=0.69 as=0.0567 ps=0.69 w=0.42 l=0.15
X660 a_3481_2767# a_3164_2223# DGND.t645 DGND.t644 sky130_fd_pr__nfet_01v8 ad=0.063 pd=0.72 as=0.1596 ps=1.6 w=0.42 l=0.15
X661 a_1775_4118# a_2235_1256# a_2193_1135# DVDD.t361 sky130_fd_pr__pfet_01v8 ad=0.0567 pd=0.69 as=0.063 ps=0.72 w=0.42 l=0.15
X662 a_3573_1501# a_3537_1367# DGND.t619 DGND.t618 sky130_fd_pr__nfet_01v8 ad=0.063 pd=0.72 as=0.1596 ps=1.6 w=0.42 l=0.15
X663 a_3076_5487# a_2325_5713# a_2980_5487# DVDD.t24 sky130_fd_pr__pfet_01v8 ad=0.0441 pd=0.63 as=0.0693 ps=0.75 w=0.42 l=0.15
X664 a_6219_4943# a_5653_5095# DGND.t484 DGND.t483 sky130_fd_pr__nfet_01v8 ad=0.06195 pd=0.715 as=0.0567 ps=0.69 w=0.42 l=0.15
X665 a_3931_4221# a_3799_4118# DVDD.t7 DVDD.t6 sky130_fd_pr__pfet_01v8 ad=0.1092 pd=1.36 as=0.0567 ps=0.69 w=0.42 l=0.15
X666 a_1733_4943# a_1697_5095.t3 DGND.t81 DGND.t80 sky130_fd_pr__nfet_01v8 ad=0.063 pd=0.72 as=0.1596 ps=1.6 w=0.42 l=0.15
X667 a_2244_2767# a_1039_1942# a_1987_2767# DGND.t529 sky130_fd_pr__nfet_01v8 ad=0.0693 pd=0.75 as=0.06195 ps=0.715 w=0.42 l=0.15
X668 a_355_1653# a_395_2344# a_353_2589# DGND.t466 sky130_fd_pr__nfet_01v8 ad=0.0567 pd=0.69 as=0.063 ps=0.72 w=0.42 l=0.15
X669 DGND.t701 a_409_3543# a_619_3677# DGND.t700 sky130_fd_pr__nfet_01v8 ad=0.0567 pd=0.69 as=0.0567 ps=0.69 w=0.42 l=0.15
X670 DVDD.t502 a0.t6 a_248_4631# DVDD.t501 sky130_fd_pr__pfet_01v8 ad=0.26 pd=2.52 as=0.135 ps=1.27 w=1 l=0.15
X671 a_4252_6397# a_2980_5487# a_4180_6397# DVDD.t668 sky130_fd_pr__pfet_01v8 ad=0.0693 pd=0.75 as=0.0441 ps=0.63 w=0.42 l=0.15
X672 a_3537_6807# a_3387_6031# a_3827_6031# DGND.t208 sky130_fd_pr__nfet_01v8 ad=0.0693 pd=0.75 as=0.06195 ps=0.715 w=0.42 l=0.15
X673 a_4839_5309# a_3072_4399# DVDD.t929 DVDD.t928 sky130_fd_pr__pfet_01v8 ad=0.06195 pd=0.715 as=0.0567 ps=0.69 w=0.42 l=0.15
X674 DVDD.t368 a5.t9 a_2249_3543# DVDD.t367 sky130_fd_pr__pfet_01v8 ad=0.26 pd=2.52 as=0.135 ps=1.27 w=1 l=0.15
X675 a_3471_1679# DGND.t562 a_2235_1256# DGND.t563 sky130_fd_pr__nfet_01v8 ad=0.0567 pd=0.69 as=0.0567 ps=0.69 w=0.42 l=0.15
X676 a_3537_1367# a_2235_1256# a_3827_2045# DVDD.t360 sky130_fd_pr__pfet_01v8 ad=0.0693 pd=0.75 as=0.06195 ps=0.715 w=0.42 l=0.15
X677 a_1420_5853# DGND.t560 a_984_6183# DGND.t561 sky130_fd_pr__nfet_01v8 ad=0.0441 pd=0.63 as=0.0693 ps=0.75 w=0.42 l=0.15
X678 DGND.t482 a_5653_5095# a_6644_4943# DGND.t481 sky130_fd_pr__nfet_01v8 ad=0.1176 pd=1.4 as=0.0693 ps=0.75 w=0.42 l=0.15
X679 DVDD.t297 a_3609_4399# a_4115_4399# DVDD.t296 sky130_fd_pr__pfet_01v8 ad=0.0567 pd=0.69 as=0.0567 ps=0.69 w=0.42 l=0.15
X680 a_2263_957# a_1697_743# DVDD.t216 DVDD.t215 sky130_fd_pr__pfet_01v8 ad=0.06195 pd=0.715 as=0.0567 ps=0.69 w=0.42 l=0.15
X681 DGND.t625 a_5009_6183# a_6000_6031# DGND.t624 sky130_fd_pr__nfet_01v8 ad=0.1176 pd=1.4 as=0.0693 ps=0.75 w=0.42 l=0.15
X682 a_2193_5487# a_2157_5719# DVDD.t378 DVDD.t377 sky130_fd_pr__pfet_01v8 ad=0.063 pd=0.72 as=0.1575 ps=1.59 w=0.42 l=0.15
X683 a_5265_4719# b4.t5 DGND.t161 DGND.t160 sky130_fd_pr__nfet_01v8 ad=0.08775 pd=0.92 as=0.169 ps=1.82 w=0.65 l=0.15
X684 DGND.t78 a_2417_4625# a_2815_4765# DGND.t77 sky130_fd_pr__nfet_01v8 ad=0.0567 pd=0.69 as=0.0567 ps=0.69 w=0.42 l=0.15
X685 DGND.t771 a_1692_4399# a_5311_3855# DGND.t770 sky130_fd_pr__nfet_01v8 ad=0.0567 pd=0.69 as=0.0567 ps=0.69 w=0.42 l=0.15
X686 a_3813_3543# b4.t6 DVDD.t395 DVDD.t394 sky130_fd_pr__pfet_01v8 ad=0.135 pd=1.27 as=0.26 ps=2.52 w=1 l=0.15
X687 a_1251_1501# a_763_1256# DGND.t287 DGND.t286 sky130_fd_pr__nfet_01v8 ad=0.0567 pd=0.69 as=0.1092 ps=1.36 w=0.42 l=0.15
X688 a_3260_2589# a_1125_3017# a_3164_2223# DGND.t435 sky130_fd_pr__nfet_01v8 ad=0.0441 pd=0.63 as=0.0693 ps=0.75 w=0.42 l=0.15
X689 a_3983_5608# b4.t7 DVDD.t397 DVDD.t396 sky130_fd_pr__pfet_01v8 ad=0.135 pd=1.27 as=0.26 ps=2.52 w=1 l=0.15
X690 a_1823_3855# a_1775_4118# a_1733_3855# DGND.t694 sky130_fd_pr__nfet_01v8 ad=0.0567 pd=0.69 as=0.063 ps=0.72 w=0.42 l=0.15
X691 a_5095_1929# a_1775_854# DGND.t547 DGND.t546 sky130_fd_pr__nfet_01v8 ad=0.08775 pd=0.92 as=0.169 ps=1.82 w=0.65 l=0.15
X692 DGND.t425 a_1455_6031# a_3827_6031# DGND.t424 sky130_fd_pr__nfet_01v8 ad=0.0567 pd=0.69 as=0.0567 ps=0.69 w=0.42 l=0.15
X693 a_1604_1501# DVDD.t963 a_1508_1135# DGND.t744 sky130_fd_pr__nfet_01v8 ad=0.0441 pd=0.63 as=0.0693 ps=0.75 w=0.42 l=0.15
X694 DVDD.t621 DGND.t906 a_3827_2045# DVDD.t620 sky130_fd_pr__pfet_01v8 ad=0.0567 pd=0.69 as=0.0567 ps=0.69 w=0.42 l=0.15
X695 a_395_854# a_3663_1135# DVDD.t259 DVDD.t258 sky130_fd_pr__pfet_01v8 ad=0.26 pd=2.52 as=0.26 ps=2.52 w=1 l=0.15
X696 a_1455_6031# a_481_6281# a_1365_6397# DVDD.t872 sky130_fd_pr__pfet_01v8 ad=0.0567 pd=0.69 as=0.063 ps=0.72 w=0.42 l=0.15
X697 DVDD.t466 a_2249_3543# a_2459_3311# DVDD.t465 sky130_fd_pr__pfet_01v8 ad=0.0567 pd=0.69 as=0.0567 ps=0.69 w=0.42 l=0.15
X698 DVDD.t214 a_1697_743# a_5177_1929# DVDD.t213 sky130_fd_pr__pfet_01v8 ad=0.135 pd=1.27 as=0.135 ps=1.27 w=1 l=0.15
X699 a_297_4105# b5.t8 DVDD.t567 DVDD.t566 sky130_fd_pr__pfet_01v8 ad=0.135 pd=1.27 as=0.26 ps=2.52 w=1 l=0.15
X700 a_3168_3311# a_849_4105# a_3072_3311# DVDD.t164 sky130_fd_pr__pfet_01v8 ad=0.0441 pd=0.63 as=0.0693 ps=0.75 w=0.42 l=0.15
X701 DVDD.t786 DVDD.t784 a_4103_1135# DVDD.t785 sky130_fd_pr__pfet_01v8 ad=0.0567 pd=0.69 as=0.0567 ps=0.69 w=0.42 l=0.15
X702 DVDD.t134 a4.t8 a_2045_2223# DVDD.t133 sky130_fd_pr__pfet_01v8 ad=0.26 pd=2.52 as=0.135 ps=1.27 w=1 l=0.15
X703 a_1823_6575# a_1775_6696# a_1733_6575# DVDD.t473 sky130_fd_pr__pfet_01v8 ad=0.0567 pd=0.69 as=0.063 ps=0.72 w=0.42 l=0.15
X704 a_2263_5309# a_1697_5095.t4 DVDD.t596 DVDD.t595 sky130_fd_pr__pfet_01v8 ad=0.06195 pd=0.715 as=0.0567 ps=0.69 w=0.42 l=0.15
X705 a_5587_2767# a_5545_2925# a_5503_2767# DGND.t658 sky130_fd_pr__nfet_01v8 ad=0.0567 pd=0.69 as=0.0567 ps=0.69 w=0.42 l=0.15
X706 a_4023_3677# DVDD.t964 a_3523_3030# DGND.t743 sky130_fd_pr__nfet_01v8 ad=0.0567 pd=0.69 as=0.0567 ps=0.69 w=0.42 l=0.15
X707 a_3747_1135# a_3571_2767# DVDD.t11 DVDD.t10 sky130_fd_pr__pfet_01v8 ad=0.1092 pd=1.36 as=0.0567 ps=0.69 w=0.42 l=0.15
X708 a_3905_5719# a1.t7 a_3977_4943# DGND.t374 sky130_fd_pr__nfet_01v8 ad=0.169 pd=1.82 as=0.08775 ps=0.92 w=0.65 l=0.15
X709 a_685_1367# a_355_1653# a_883_2589# DGND.t672 sky130_fd_pr__nfet_01v8 ad=0.0693 pd=0.75 as=0.06195 ps=0.715 w=0.42 l=0.15
X710 DVDD.t598 a_1697_5095.t5 a_2688_5309# DVDD.t597 sky130_fd_pr__pfet_01v8 ad=0.1575 pd=1.59 as=0.0693 ps=0.75 w=0.42 l=0.15
X711 a_1400_3677# a_297_3017# a_1328_3677# DGND.t664 sky130_fd_pr__nfet_01v8 ad=0.0693 pd=0.75 as=0.0441 ps=0.63 w=0.42 l=0.15
X712 a_883_957# a_395_854# DVDD.t183 DVDD.t182 sky130_fd_pr__pfet_01v8 ad=0.0567 pd=0.69 as=0.1092 ps=1.36 w=0.42 l=0.15
X713 a_4667_957# a_4535_854# DVDD.t224 DVDD.t223 sky130_fd_pr__pfet_01v8 ad=0.1092 pd=1.36 as=0.0567 ps=0.69 w=0.42 l=0.15
X714 a_527_2223# a_395_2344# DVDD.t508 DVDD.t507 sky130_fd_pr__pfet_01v8 ad=0.1092 pd=1.36 as=0.0567 ps=0.69 w=0.42 l=0.15
X715 a_1895_6031# a_1329_6183# DGND.t834 DGND.t833 sky130_fd_pr__nfet_01v8 ad=0.06195 pd=0.715 as=0.0567 ps=0.69 w=0.42 l=0.15
X716 a_2325_5713# a1.t8 a_2689_6031# DGND.t379 sky130_fd_pr__nfet_01v8 ad=0.169 pd=1.82 as=0.08775 ps=0.92 w=0.65 l=0.15
X717 DGND.t742 DVDD.t965 a_883_4943# DGND.t741 sky130_fd_pr__nfet_01v8 ad=0.0567 pd=0.69 as=0.0567 ps=0.69 w=0.42 l=0.15
X718 a_2263_4221# a_1508_1135# DVDD.t130 DVDD.t129 sky130_fd_pr__pfet_01v8 ad=0.06195 pd=0.715 as=0.0567 ps=0.69 w=0.42 l=0.15
X719 a_2285_3311# a_2249_3543# DVDD.t464 DVDD.t463 sky130_fd_pr__pfet_01v8 ad=0.063 pd=0.72 as=0.1575 ps=1.59 w=0.42 l=0.15
X720 DVDD.t692 a_5545_2925# a_5943_3133# DVDD.t691 sky130_fd_pr__pfet_01v8 ad=0.0567 pd=0.69 as=0.0567 ps=0.69 w=0.42 l=0.15
X721 a_3571_2767# a_3523_3030# a_3481_2767# DGND.t133 sky130_fd_pr__nfet_01v8 ad=0.0567 pd=0.69 as=0.063 ps=0.72 w=0.42 l=0.15
X722 DGND.t832 a_1329_6183# a_2320_6031# DGND.t831 sky130_fd_pr__nfet_01v8 ad=0.1176 pd=1.4 as=0.0693 ps=0.75 w=0.42 l=0.15
X723 a_1079_4399# a_947_4520# DVDD.t293 DVDD.t292 sky130_fd_pr__pfet_01v8 ad=0.1092 pd=1.36 as=0.0567 ps=0.69 w=0.42 l=0.15
X724 a_3663_1135# a_3571_2767# a_3573_1501# DGND.t13 sky130_fd_pr__nfet_01v8 ad=0.0567 pd=0.69 as=0.063 ps=0.72 w=0.42 l=0.15
X725 DVDD.t633 a_4860_1367# a_1865_4013# DVDD.t632 sky130_fd_pr__pfet_01v8 ad=0.15835 pd=1.395 as=0.26 ps=2.52 w=1 l=0.15
X726 DVDD.t128 a_1508_1135# a_2688_4221# DVDD.t127 sky130_fd_pr__pfet_01v8 ad=0.1575 pd=1.59 as=0.0693 ps=0.75 w=0.42 l=0.15
X727 a_1697_6807.t1 a_5135_6031# a_5575_6397# DVDD.t34 sky130_fd_pr__pfet_01v8 ad=0.0693 pd=0.75 as=0.06195 ps=0.715 w=0.42 l=0.15
X728 a_1697_5095.t0 a_6412_5719# DGND.t731 DGND.t630 sky130_fd_pr__nfet_01v8 ad=0.169 pd=1.82 as=0.169 ps=1.82 w=0.65 l=0.15
X729 a_4103_6575# a_627_5487# DVDD.t249 DVDD.t248 sky130_fd_pr__pfet_01v8 ad=0.0567 pd=0.69 as=0.1092 ps=1.36 w=0.42 l=0.15
X730 DGND.t60 a_317_5095# a_527_4943# DGND.t59 sky130_fd_pr__nfet_01v8 ad=0.0567 pd=0.69 as=0.0567 ps=0.69 w=0.42 l=0.15
X731 a_2980_1135# a_1775_4118# a_2723_1135# DVDD.t726 sky130_fd_pr__pfet_01v8 ad=0.0693 pd=0.75 as=0.06195 ps=0.715 w=0.42 l=0.15
X732 a_4287_3855# a_3072_3311# DGND.t593 DGND.t592 sky130_fd_pr__nfet_01v8 ad=0.06195 pd=0.715 as=0.0567 ps=0.69 w=0.42 l=0.15
X733 P11.t0 a_2243_1929# a_2493_1929# DVDD.t305 sky130_fd_pr__pfet_01v8 ad=0.3 pd=2.6 as=0.26 ps=2.52 w=1 l=0.15
X734 a_1907_591# a_1775_854# DGND.t545 DGND.t544 sky130_fd_pr__nfet_01v8 ad=0.1092 pd=1.36 as=0.0567 ps=0.69 w=0.42 l=0.15
X735 a_3148_1135# a_2235_1256# a_3076_1135# DVDD.t359 sky130_fd_pr__pfet_01v8 ad=0.0693 pd=0.75 as=0.0441 ps=0.63 w=0.42 l=0.15
X736 a_4011_3133# a_3523_3030# DVDD.t146 DVDD.t145 sky130_fd_pr__pfet_01v8 ad=0.0567 pd=0.69 as=0.1092 ps=1.36 w=0.42 l=0.15
X737 DGND.t740 DVDD.t966 a_4471_5853# DGND.t739 sky130_fd_pr__nfet_01v8 ad=0.0567 pd=0.69 as=0.0567 ps=0.69 w=0.42 l=0.15
X738 a_2243_1929# a_1823_3855# DGND.t293 DGND.t292 sky130_fd_pr__nfet_01v8 ad=0.08775 pd=0.92 as=0.169 ps=1.82 w=0.65 l=0.15
X739 DGND.t591 a_3072_3311# a_4712_3855# DGND.t590 sky130_fd_pr__nfet_01v8 ad=0.1176 pd=1.4 as=0.0693 ps=0.75 w=0.42 l=0.15
X740 a_4011_3133# a_3164_2223# DVDD.t679 DVDD.t678 sky130_fd_pr__pfet_01v8 ad=0.06195 pd=0.715 as=0.0567 ps=0.69 w=0.42 l=0.15
X741 a_2283_5487# a_2235_5608# a_2193_5487# DVDD.t555 sky130_fd_pr__pfet_01v8 ad=0.0567 pd=0.69 as=0.063 ps=0.72 w=0.42 l=0.15
X742 a_6047_1679# a_1823_4943# a_4625_749# DGND.t386 sky130_fd_pr__nfet_01v8 ad=0.0567 pd=0.69 as=0.0567 ps=0.69 w=0.42 l=0.15
X743 a_6219_4943# a_4399_4943# DGND.t114 DGND.t113 sky130_fd_pr__nfet_01v8 ad=0.0567 pd=0.69 as=0.1092 ps=1.36 w=0.42 l=0.15
X744 a_1435_4765# a_757_6281# DGND.t849 DGND.t848 sky130_fd_pr__nfet_01v8 ad=0.06195 pd=0.715 as=0.0567 ps=0.69 w=0.42 l=0.15
X745 DGND.t738 DVDD.t967 a_5575_6031# DGND.t737 sky130_fd_pr__nfet_01v8 ad=0.0567 pd=0.69 as=0.0567 ps=0.69 w=0.42 l=0.15
X746 DVDD.t504 a0.t7 a_4073_4625# DVDD.t503 sky130_fd_pr__pfet_01v8 ad=0.26 pd=2.52 as=0.135 ps=1.27 w=1 l=0.15
X747 a_2459_3677# a_2327_3432# DGND.t186 DGND.t185 sky130_fd_pr__nfet_01v8 ad=0.1092 pd=1.36 as=0.0567 ps=0.69 w=0.42 l=0.15
X748 a_4575_2223# a_3847_3855# DVDD.t850 DVDD.t849 sky130_fd_pr__pfet_01v8 ad=0.1092 pd=1.36 as=0.0567 ps=0.69 w=0.42 l=0.15
X749 a_1775_5206.t1 a_5135_6031# DVDD.t33 DVDD.t32 sky130_fd_pr__pfet_01v8 ad=0.26 pd=2.52 as=0.26 ps=2.52 w=1 l=0.15
X750 a_3891_3432# a1.t9 a_6737_3855# DGND.t380 sky130_fd_pr__nfet_01v8 ad=0.169 pd=1.82 as=0.08775 ps=0.92 w=0.65 l=0.15
X751 a_4793_1679# a_4751_1831# a_4709_1679# DGND.t390 sky130_fd_pr__nfet_01v8 ad=0.08775 pd=0.92 as=0.08775 ps=0.92 w=0.65 l=0.15
X752 a_4896_4399# a_3983_4520# a_4824_4399# DVDD.t151 sky130_fd_pr__pfet_01v8 ad=0.0693 pd=0.75 as=0.0441 ps=0.63 w=0.42 l=0.15
X753 a_1527_1679# a_961_1831# DGND.t480 DGND.t479 sky130_fd_pr__nfet_01v8 ad=0.06195 pd=0.715 as=0.0567 ps=0.69 w=0.42 l=0.15
X754 a_3537_6807# a_3387_6031# a_3827_6397# DVDD.t232 sky130_fd_pr__pfet_01v8 ad=0.0693 pd=0.75 as=0.06195 ps=0.715 w=0.42 l=0.15
X755 a_2815_4399# a_2249_4631# DVDD.t94 DVDD.t93 sky130_fd_pr__pfet_01v8 ad=0.06195 pd=0.715 as=0.0567 ps=0.69 w=0.42 l=0.15
X756 DVDD.t677 a_3164_2223# a_4436_3133# DVDD.t676 sky130_fd_pr__pfet_01v8 ad=0.1575 pd=1.59 as=0.0693 ps=0.75 w=0.42 l=0.15
X757 a_5023_957# a_4535_854# DVDD.t222 DVDD.t221 sky130_fd_pr__pfet_01v8 ad=0.0567 pd=0.69 as=0.1092 ps=1.36 w=0.42 l=0.15
X758 DVDD.t410 a_1823_4943# a_6403_2045# DVDD.t409 sky130_fd_pr__pfet_01v8 ad=0.0567 pd=0.69 as=0.0567 ps=0.69 w=0.42 l=0.15
X759 DGND.t623 a_5009_6183# a_5219_6031# DGND.t622 sky130_fd_pr__nfet_01v8 ad=0.0567 pd=0.69 as=0.0567 ps=0.69 w=0.42 l=0.15
X760 a_6572_4943# a_5821_5101# a_6412_5719# DGND.t788 sky130_fd_pr__nfet_01v8 ad=0.0441 pd=0.63 as=0.0693 ps=0.75 w=0.42 l=0.15
X761 a_2688_3855# a_1775_4118# a_2616_3855# DGND.t693 sky130_fd_pr__nfet_01v8 ad=0.0693 pd=0.75 as=0.0441 ps=0.63 w=0.42 l=0.15
X762 a_975_3311# a_409_3543# DVDD.t734 DVDD.t733 sky130_fd_pr__pfet_01v8 ad=0.06195 pd=0.715 as=0.0567 ps=0.69 w=0.42 l=0.15
X763 DVDD.t563 a3.t7 a_1037_4625# DVDD.t562 sky130_fd_pr__pfet_01v8 ad=0.26 pd=2.52 as=0.135 ps=1.27 w=1 l=0.15
X764 DVDD.t372 a_3813_3543# a_4804_3311# DVDD.t371 sky130_fd_pr__pfet_01v8 ad=0.1575 pd=1.59 as=0.0693 ps=0.75 w=0.42 l=0.15
X765 DVDD.t661 a_5009_6183# a_6000_6397# DVDD.t660 sky130_fd_pr__pfet_01v8 ad=0.1575 pd=1.59 as=0.0693 ps=0.75 w=0.42 l=0.15
X766 a_5227_3855# a_4031_5487# a_5137_3855# DGND.t363 sky130_fd_pr__nfet_01v8 ad=0.0567 pd=0.69 as=0.063 ps=0.72 w=0.42 l=0.15
X767 a_527_591# a_485_749# a_443_591# DGND.t313 sky130_fd_pr__nfet_01v8 ad=0.0567 pd=0.69 as=0.0567 ps=0.69 w=0.42 l=0.15
X768 a_849_3855# b3.t7 DGND.t800 DGND.t799 sky130_fd_pr__nfet_01v8 ad=0.08775 pd=0.92 as=0.169 ps=1.82 w=0.65 l=0.15
X769 a_3757_4221# a_3072_3311# DVDD.t631 DVDD.t630 sky130_fd_pr__pfet_01v8 ad=0.063 pd=0.72 as=0.1575 ps=1.59 w=0.42 l=0.15
X770 a_1236_2223# DGND.t907 a_685_1367# DVDD.t622 sky130_fd_pr__pfet_01v8 ad=0.0441 pd=0.63 as=0.0693 ps=0.75 w=0.42 l=0.15
X771 a_3799_4118# a_3983_4520# a_3941_4399# DVDD.t150 sky130_fd_pr__pfet_01v8 ad=0.0567 pd=0.69 as=0.063 ps=0.72 w=0.42 l=0.15
X772 DVDD.t732 a_409_3543# a_1400_3311# DVDD.t731 sky130_fd_pr__pfet_01v8 ad=0.1575 pd=1.59 as=0.0693 ps=0.75 w=0.42 l=0.15
X773 a_1631_2767# a_849_3017# DGND.t456 DGND.t455 sky130_fd_pr__nfet_01v8 ad=0.1092 pd=1.36 as=0.0567 ps=0.69 w=0.42 l=0.15
X774 a_1329_6183# a2.t8 a_1401_6895# DGND.t393 sky130_fd_pr__nfet_01v8 ad=0.169 pd=1.82 as=0.08775 ps=0.92 w=0.65 l=0.15
X775 a_2688_6575# a_1775_6696# a_2616_6575# DVDD.t472 sky130_fd_pr__pfet_01v8 ad=0.0693 pd=0.75 as=0.0441 ps=0.63 w=0.42 l=0.15
X776 DVDD.t449 a_1455_6031# a_3827_6397# DVDD.t448 sky130_fd_pr__pfet_01v8 ad=0.0567 pd=0.69 as=0.0567 ps=0.69 w=0.42 l=0.15
X777 a_2045_2543# b3.t8 DGND.t802 DGND.t801 sky130_fd_pr__nfet_01v8 ad=0.08775 pd=0.92 as=0.169 ps=1.82 w=0.65 l=0.15
X778 a_1401_3855# b1.t7 DGND.t163 DGND.t162 sky130_fd_pr__nfet_01v8 ad=0.08775 pd=0.92 as=0.169 ps=1.82 w=0.65 l=0.15
X779 a_2375_3311# a_2327_3432# a_2285_3311# DVDD.t201 sky130_fd_pr__pfet_01v8 ad=0.0567 pd=0.69 as=0.063 ps=0.72 w=0.42 l=0.15
X780 a_883_591# a_317_743# DGND.t317 DGND.t316 sky130_fd_pr__nfet_01v8 ad=0.06195 pd=0.715 as=0.0567 ps=0.69 w=0.42 l=0.15
X781 a_1171_2045# DGND.t908 a_763_1256# DVDD.t623 sky130_fd_pr__pfet_01v8 ad=0.0567 pd=0.69 as=0.0567 ps=0.69 w=0.42 l=0.15
X782 a_2325_5713# b2.t7 DVDD.t719 DVDD.t718 sky130_fd_pr__pfet_01v8 ad=0.135 pd=1.27 as=0.26 ps=2.52 w=1 l=0.15
X783 a_5837_1831# a_5503_2767# a_5943_2767# DGND.t26 sky130_fd_pr__nfet_01v8 ad=0.0693 pd=0.75 as=0.06195 ps=0.715 w=0.42 l=0.15
X784 a_2263_5309# a_1775_5206.t4 DVDD.t593 DVDD.t592 sky130_fd_pr__pfet_01v8 ad=0.0567 pd=0.69 as=0.1092 ps=1.36 w=0.42 l=0.15
X785 a_3977_4943# b3.t9 DGND.t238 DGND.t237 sky130_fd_pr__nfet_01v8 ad=0.08775 pd=0.92 as=0.169 ps=1.82 w=0.65 l=0.15
X786 a_6173_2543# a_5188_2223# DGND.t165 DGND.t164 sky130_fd_pr__nfet_01v8 ad=0.08775 pd=0.92 as=0.08775 ps=0.92 w=0.65 l=0.15
X787 a_4943_1653# a_5923_2223# a_6173_2223# DVDD.t304 sky130_fd_pr__pfet_01v8 ad=0.3 pd=2.6 as=0.26 ps=2.52 w=1 l=0.15
X788 DGND.t670 a_1497_6189# a_1895_6031# DGND.t669 sky130_fd_pr__nfet_01v8 ad=0.0567 pd=0.69 as=0.0567 ps=0.69 w=0.42 l=0.15
X789 DGND.t92 a_501_5719# a_711_5853# DGND.t91 sky130_fd_pr__nfet_01v8 ad=0.0567 pd=0.69 as=0.0567 ps=0.69 w=0.42 l=0.15
X790 a_6277_4719# b0.t7 DGND.t692 DGND.t691 sky130_fd_pr__nfet_01v8 ad=0.08775 pd=0.92 as=0.169 ps=1.82 w=0.65 l=0.15
X791 a_1329_6183# b0.t8 DVDD.t881 DVDD.t880 sky130_fd_pr__pfet_01v8 ad=0.135 pd=1.27 as=0.26 ps=2.52 w=1 l=0.15
X792 DVDD.t17 a_1697_5095.t6 a_1907_5309# DVDD.t16 sky130_fd_pr__pfet_01v8 ad=0.0567 pd=0.69 as=0.0567 ps=0.69 w=0.42 l=0.15
X793 a_4471_4765# a_3609_4399# DGND.t277 DGND.t276 sky130_fd_pr__nfet_01v8 ad=0.06195 pd=0.715 as=0.0567 ps=0.69 w=0.42 l=0.15
X794 a_4533_2449# a2.t9 a_5081_2767# DGND.t394 sky130_fd_pr__nfet_01v8 ad=0.169 pd=1.82 as=0.08775 ps=0.92 w=0.65 l=0.15
X795 DVDD.t935 a_4457_743# a_4667_957# DVDD.t934 sky130_fd_pr__pfet_01v8 ad=0.0567 pd=0.69 as=0.0567 ps=0.69 w=0.42 l=0.15
X796 a_2616_5309# a_1823_6575# P5.t0 DVDD.t270 sky130_fd_pr__pfet_01v8 ad=0.0441 pd=0.63 as=0.0693 ps=0.75 w=0.42 l=0.15
X797 a_6644_5309# a_4399_4943# a_6572_5309# DVDD.t118 sky130_fd_pr__pfet_01v8 ad=0.0693 pd=0.75 as=0.0441 ps=0.63 w=0.42 l=0.15
X798 a_527_2223# DGND.t909 a_355_1653# DVDD.t84 sky130_fd_pr__pfet_01v8 ad=0.0567 pd=0.69 as=0.0567 ps=0.69 w=0.42 l=0.15
X799 a_1895_6397# a_1329_6183# DVDD.t888 DVDD.t887 sky130_fd_pr__pfet_01v8 ad=0.06195 pd=0.715 as=0.0567 ps=0.69 w=0.42 l=0.15
X800 a_4436_2767# a_3523_3030# a_4364_2767# DGND.t132 sky130_fd_pr__nfet_01v8 ad=0.0693 pd=0.75 as=0.0441 ps=0.63 w=0.42 l=0.15
X801 a_4931_2589# a_4268_2767# DGND.t867 DGND.t866 sky130_fd_pr__nfet_01v8 ad=0.06195 pd=0.715 as=0.0567 ps=0.69 w=0.42 l=0.15
X802 a_4839_4943# a_3072_4399# DGND.t875 DGND.t874 sky130_fd_pr__nfet_01v8 ad=0.06195 pd=0.715 as=0.0567 ps=0.69 w=0.42 l=0.15
X803 a_6020_4221# a_2375_4399# a_5653_5095# DVDD.t442 sky130_fd_pr__pfet_01v8 ad=0.0441 pd=0.63 as=0.0693 ps=0.75 w=0.42 l=0.15
X804 DVDD.t42 a_5289_1433# a_5319_1174# DVDD.t41 sky130_fd_pr__pfet_01v8 ad=0.0693 pd=0.75 as=0.0441 ps=0.63 w=0.42 l=0.15
X805 DGND.t830 a_1329_6183# a_1539_6031# DGND.t829 sky130_fd_pr__nfet_01v8 ad=0.0567 pd=0.69 as=0.0567 ps=0.69 w=0.42 l=0.15
X806 a_5821_5101# a_4728_4399# DVDD.t75 DVDD.t74 sky130_fd_pr__pfet_01v8 ad=0.26 pd=2.52 as=0.26 ps=2.52 w=1 l=0.15
X807 a_2263_4221# a_1775_4118# DVDD.t725 DVDD.t724 sky130_fd_pr__pfet_01v8 ad=0.0567 pd=0.69 as=0.1092 ps=1.36 w=0.42 l=0.15
X808 DVDD.t830 a_1692_4399# a_6092_4221# DVDD.t829 sky130_fd_pr__pfet_01v8 ad=0.1575 pd=1.59 as=0.0693 ps=0.75 w=0.42 l=0.15
X809 DVDD.t456 a_1865_749# a_2263_957# DVDD.t455 sky130_fd_pr__pfet_01v8 ad=0.0567 pd=0.69 as=0.0567 ps=0.69 w=0.42 l=0.15
X810 DVDD.t886 a_1329_6183# a_2320_6397# DVDD.t885 sky130_fd_pr__pfet_01v8 ad=0.1575 pd=1.59 as=0.0693 ps=0.75 w=0.42 l=0.15
X811 a_3517_4943# b2.t8 DGND.t226 DGND.t225 sky130_fd_pr__nfet_01v8 ad=0.08775 pd=0.92 as=0.169 ps=1.82 w=0.65 l=0.15
X812 a_4115_4765# a_3983_4520# DGND.t141 DGND.t140 sky130_fd_pr__nfet_01v8 ad=0.1092 pd=1.36 as=0.0567 ps=0.69 w=0.42 l=0.15
X813 a_1079_4399# a_1037_4625# a_995_4399# DVDD.t746 sky130_fd_pr__pfet_01v8 ad=0.0567 pd=0.69 as=0.0567 ps=0.69 w=0.42 l=0.15
X814 DGND.t52 a_685_1367# a_895_1501# DGND.t51 sky130_fd_pr__nfet_01v8 ad=0.0567 pd=0.69 as=0.0567 ps=0.69 w=0.42 l=0.15
X815 DVDD.t126 a_1508_1135# a_1907_4221# DVDD.t125 sky130_fd_pr__pfet_01v8 ad=0.0567 pd=0.69 as=0.0567 ps=0.69 w=0.42 l=0.15
X816 a_2616_4221# a_1865_4013# a_2520_3855# DVDD.t430 sky130_fd_pr__pfet_01v8 ad=0.0441 pd=0.63 as=0.0693 ps=0.75 w=0.42 l=0.15
X817 DGND.t312 a_485_749# a_883_591# DGND.t311 sky130_fd_pr__nfet_01v8 ad=0.0567 pd=0.69 as=0.0567 ps=0.69 w=0.42 l=0.15
X818 a_4636_3311# a_3523_3030# a_4379_3311# DVDD.t144 sky130_fd_pr__pfet_01v8 ad=0.0693 pd=0.75 as=0.06195 ps=0.715 w=0.42 l=0.15
X819 DGND.t865 a_4268_2767# a_5356_2589# DGND.t864 sky130_fd_pr__nfet_01v8 ad=0.1176 pd=1.4 as=0.0693 ps=0.75 w=0.42 l=0.15
X820 a_2980_5487# a_2283_5487# a_2723_5487# DVDD.t572 sky130_fd_pr__pfet_01v8 ad=0.0693 pd=0.75 as=0.06195 ps=0.715 w=0.42 l=0.15
X821 a_4287_3855# a_3799_4118# DGND.t3 DGND.t2 sky130_fd_pr__nfet_01v8 ad=0.0567 pd=0.69 as=0.1092 ps=1.36 w=0.42 l=0.15
X822 a_3849_3677# a_3813_3543# DGND.t348 DGND.t347 sky130_fd_pr__nfet_01v8 ad=0.063 pd=0.72 as=0.1596 ps=1.6 w=0.42 l=0.15
X823 a_3148_5487# a_2235_5608# a_3076_5487# DVDD.t554 sky130_fd_pr__pfet_01v8 ad=0.0693 pd=0.75 as=0.0441 ps=0.63 w=0.42 l=0.15
X824 DGND.t589 a_3072_3311# a_3931_3855# DGND.t588 sky130_fd_pr__nfet_01v8 ad=0.0567 pd=0.69 as=0.0567 ps=0.69 w=0.42 l=0.15
X825 a_5587_3133# a_5227_3855# DVDD.t69 DVDD.t68 sky130_fd_pr__pfet_01v8 ad=0.1092 pd=1.36 as=0.0567 ps=0.69 w=0.42 l=0.15
X826 DVDD.t838 a_3905_5719# a_4896_5487# DVDD.t837 sky130_fd_pr__pfet_01v8 ad=0.1575 pd=1.59 as=0.0693 ps=0.75 w=0.42 l=0.15
X827 a_1067_5487# a_501_5719# DVDD.t100 DVDD.t99 sky130_fd_pr__pfet_01v8 ad=0.06195 pd=0.715 as=0.0567 ps=0.69 w=0.42 l=0.15
X828 DVDD.t855 a0.t8 a_1497_6189# DVDD.t854 sky130_fd_pr__pfet_01v8 ad=0.26 pd=2.52 as=0.135 ps=1.27 w=1 l=0.15
X829 a_4103_1501# a_3537_1367# DGND.t617 DGND.t616 sky130_fd_pr__nfet_01v8 ad=0.06195 pd=0.715 as=0.0567 ps=0.69 w=0.42 l=0.15
X830 a_2263_4943# a_1697_5095.t7 DGND.t17 DGND.t16 sky130_fd_pr__nfet_01v8 ad=0.06195 pd=0.715 as=0.0567 ps=0.69 w=0.42 l=0.15
X831 a_1907_6941# a_1775_6696# DGND.t446 DGND.t445 sky130_fd_pr__nfet_01v8 ad=0.1092 pd=1.36 as=0.0567 ps=0.69 w=0.42 l=0.15
X832 DVDD.t416 a3.t8 a_849_4105# DVDD.t415 sky130_fd_pr__pfet_01v8 ad=0.26 pd=2.52 as=0.135 ps=1.27 w=1 l=0.15
X833 a_3847_3855# a_3799_4118# a_3757_4221# DVDD.t5 sky130_fd_pr__pfet_01v8 ad=0.0567 pd=0.69 as=0.063 ps=0.72 w=0.42 l=0.15
X834 a_4860_1367# a_443_591# a_5002_1501# DGND.t257 sky130_fd_pr__nfet_01v8 ad=0.09975 pd=0.895 as=0.0693 ps=0.75 w=0.42 l=0.15
X835 DGND.t615 a_3537_1367# a_4528_1501# DGND.t614 sky130_fd_pr__nfet_01v8 ad=0.1176 pd=1.4 as=0.0693 ps=0.75 w=0.42 l=0.15
X836 DVDD.t783 DVDD.t781 a_5575_6397# DVDD.t782 sky130_fd_pr__pfet_01v8 ad=0.0567 pd=0.69 as=0.0567 ps=0.69 w=0.42 l=0.15
X837 a_1492_5853# a_443_4943# a_1420_5853# DGND.t678 sky130_fd_pr__nfet_01v8 ad=0.0693 pd=0.75 as=0.0441 ps=0.63 w=0.42 l=0.15
X838 DVDD.t98 a_501_5719# a_1492_5487# DVDD.t97 sky130_fd_pr__pfet_01v8 ad=0.1575 pd=1.59 as=0.0693 ps=0.75 w=0.42 l=0.15
X839 a_4640_3855# a_995_4399# a_4544_3855# DGND.t128 sky130_fd_pr__nfet_01v8 ad=0.0441 pd=0.63 as=0.0693 ps=0.75 w=0.42 l=0.15
X840 DVDD.t136 a4.t9 a_2327_3432# DVDD.t135 sky130_fd_pr__pfet_01v8 ad=0.26 pd=2.52 as=0.135 ps=1.27 w=1 l=0.15
X841 a_4575_2223# a_4533_2449# a_1775_854# DVDD.t156 sky130_fd_pr__pfet_01v8 ad=0.0567 pd=0.69 as=0.0567 ps=0.69 w=0.42 l=0.15
X842 a_6000_6031# a_3387_6031# a_5928_6031# DGND.t207 sky130_fd_pr__nfet_01v8 ad=0.0693 pd=0.75 as=0.0441 ps=0.63 w=0.42 l=0.15
X843 DGND.t222 a_1697_5095.t8 a_2688_4943# DGND.t221 sky130_fd_pr__nfet_01v8 ad=0.1176 pd=1.4 as=0.0693 ps=0.75 w=0.42 l=0.15
X844 a_1769_3631# b2.t9 DGND.t228 DGND.t227 sky130_fd_pr__nfet_01v8 ad=0.08775 pd=0.92 as=0.169 ps=1.82 w=0.65 l=0.15
X845 a_4728_4399# a_3799_4118# a_4471_4399# DVDD.t4 sky130_fd_pr__pfet_01v8 ad=0.0693 pd=0.75 as=0.06195 ps=0.715 w=0.42 l=0.15
X846 DVDD.t780 DVDD.t778 a_2723_1135# DVDD.t779 sky130_fd_pr__pfet_01v8 ad=0.0567 pd=0.69 as=0.0567 ps=0.69 w=0.42 l=0.15
X847 a_297_4105# a5.t10 a_297_3855# DGND.t106 sky130_fd_pr__nfet_01v8 ad=0.169 pd=1.82 as=0.08775 ps=0.92 w=0.65 l=0.15
X848 a_5653_5095# a_5227_3855# a_5667_3855# DGND.t69 sky130_fd_pr__nfet_01v8 ad=0.0693 pd=0.75 as=0.06195 ps=0.715 w=0.42 l=0.15
X849 a_4751_1831# a_3663_1135# a_6173_1455# DGND.t240 sky130_fd_pr__nfet_01v8 ad=0.25025 pd=1.42 as=0.08775 ps=0.92 w=0.65 l=0.15
X850 a_3332_2589# a_2045_2223# a_3260_2589# DGND.t888 sky130_fd_pr__nfet_01v8 ad=0.0693 pd=0.75 as=0.0441 ps=0.63 w=0.42 l=0.15
X851 a_4364_3133# a_2375_3311# a_4268_2767# DVDD.t494 sky130_fd_pr__pfet_01v8 ad=0.0441 pd=0.63 as=0.0693 ps=0.75 w=0.42 l=0.15
X852 a_1527_1679# a_1039_1942# DGND.t528 DGND.t527 sky130_fd_pr__nfet_01v8 ad=0.0567 pd=0.69 as=0.1092 ps=1.36 w=0.42 l=0.15
X853 DVDD.t856 a0.t9 a_3517_5487# DVDD.t333 sky130_fd_pr__pfet_01v8 ad=0.26 pd=2.52 as=0.135 ps=1.27 w=1 l=0.15
X854 a_2815_4399# a_2327_4520# DVDD.t47 DVDD.t46 sky130_fd_pr__pfet_01v8 ad=0.0567 pd=0.69 as=0.1092 ps=1.36 w=0.42 l=0.15
X855 DVDD.t114 a5.t11 a_2341_2455# DVDD.t113 sky130_fd_pr__pfet_01v8 ad=0.26 pd=2.52 as=0.135 ps=1.27 w=1 l=0.15
X856 DGND.t559 DGND.t557 a_883_2589# DGND.t558 sky130_fd_pr__nfet_01v8 ad=0.0567 pd=0.69 as=0.0567 ps=0.69 w=0.42 l=0.15
X857 DVDD.t659 a_5009_6183# a_5219_6397# DVDD.t658 sky130_fd_pr__pfet_01v8 ad=0.0567 pd=0.69 as=0.0567 ps=0.69 w=0.42 l=0.15
X858 a_757_6031# b0.t9 DGND.t826 DGND.t825 sky130_fd_pr__nfet_01v8 ad=0.08775 pd=0.92 as=0.169 ps=1.82 w=0.65 l=0.15
X859 a_1676_1501# a_763_1256# a_1604_1501# DGND.t285 sky130_fd_pr__nfet_01v8 ad=0.0693 pd=0.75 as=0.0441 ps=0.63 w=0.42 l=0.15
X860 a_895_1135# a_763_1256# DVDD.t307 DVDD.t306 sky130_fd_pr__pfet_01v8 ad=0.1092 pd=1.36 as=0.0567 ps=0.69 w=0.42 l=0.15
X861 P10.t1 a_2520_3855# DVDD.t112 DVDD.t111 sky130_fd_pr__pfet_01v8 ad=0.26 pd=2.52 as=0.26 ps=2.52 w=1 l=0.15
X862 a_6173_1135# a_2980_1135# DVDD.t858 DVDD.t857 sky130_fd_pr__pfet_01v8 ad=0.135 pd=1.27 as=0.135 ps=1.27 w=1 l=0.15
X863 a_3827_1679# a_2244_2767# DGND.t416 DGND.t415 sky130_fd_pr__nfet_01v8 ad=0.06195 pd=0.715 as=0.0567 ps=0.69 w=0.42 l=0.15
X864 a_1328_3311# DVDD.t776 a_961_1831# DVDD.t777 sky130_fd_pr__pfet_01v8 ad=0.0441 pd=0.63 as=0.0693 ps=0.75 w=0.42 l=0.15
X865 a_2412_2767# a_849_3017# a_2340_2767# DGND.t454 sky130_fd_pr__nfet_01v8 ad=0.0693 pd=0.75 as=0.0441 ps=0.63 w=0.42 l=0.15
X866 a_2263_591# a_1697_743# DGND.t192 DGND.t191 sky130_fd_pr__nfet_01v8 ad=0.06195 pd=0.715 as=0.0567 ps=0.69 w=0.42 l=0.15
X867 DGND.t533 a_317_2455# a_527_2589# DGND.t532 sky130_fd_pr__nfet_01v8 ad=0.0567 pd=0.69 as=0.0567 ps=0.69 w=0.42 l=0.15
X868 DVDD.t927 a_3072_4399# a_4483_5309# DVDD.t926 sky130_fd_pr__pfet_01v8 ad=0.0567 pd=0.69 as=0.0567 ps=0.69 w=0.42 l=0.15
X869 a_573_2767# b4.t8 DGND.t378 DGND.t377 sky130_fd_pr__nfet_01v8 ad=0.08775 pd=0.92 as=0.169 ps=1.82 w=0.65 l=0.15
X870 a_1880_1679# DGND.t555 a_1784_1679# DGND.t556 sky130_fd_pr__nfet_01v8 ad=0.0441 pd=0.63 as=0.0693 ps=0.75 w=0.42 l=0.15
X871 a_3481_3133# a_3164_2223# DVDD.t675 DVDD.t674 sky130_fd_pr__pfet_01v8 ad=0.063 pd=0.72 as=0.1575 ps=1.59 w=0.42 l=0.15
X872 DGND.t478 a_961_1831# a_1952_1679# DGND.t477 sky130_fd_pr__nfet_01v8 ad=0.1176 pd=1.4 as=0.0693 ps=0.75 w=0.42 l=0.15
X873 DVDD.t92 a_2249_4631# a_3240_4399# DVDD.t91 sky130_fd_pr__pfet_01v8 ad=0.1575 pd=1.59 as=0.0693 ps=0.75 w=0.42 l=0.15
X874 a_3240_4765# a_2327_4520# a_3168_4765# DGND.t47 sky130_fd_pr__nfet_01v8 ad=0.0693 pd=0.75 as=0.0441 ps=0.63 w=0.42 l=0.15
X875 a_2244_2767# a_1039_1942# a_1987_3133# DVDD.t579 sky130_fd_pr__pfet_01v8 ad=0.0693 pd=0.75 as=0.06195 ps=0.715 w=0.42 l=0.15
X876 P4.t1 a_2520_6575# DVDD.t667 DVDD.t666 sky130_fd_pr__pfet_01v8 ad=0.26 pd=2.52 as=0.26 ps=2.52 w=1 l=0.15
X877 a_2459_4765# a_2417_4625# a_2375_4399# DGND.t76 sky130_fd_pr__nfet_01v8 ad=0.0567 pd=0.69 as=0.0567 ps=0.69 w=0.42 l=0.15
X878 a_1631_2767# a_573_4105# a_1039_1942# DGND.t305 sky130_fd_pr__nfet_01v8 ad=0.0567 pd=0.69 as=0.0567 ps=0.69 w=0.42 l=0.15
X879 a_481_6281# b1.t8 DVDD.t171 DVDD.t170 sky130_fd_pr__pfet_01v8 ad=0.135 pd=1.27 as=0.26 ps=2.52 w=1 l=0.15
X880 DVDD.t702 a_1497_6189# a_1895_6397# DVDD.t701 sky130_fd_pr__pfet_01v8 ad=0.0567 pd=0.69 as=0.0567 ps=0.69 w=0.42 l=0.15
X881 a_627_5487# a_443_4943# a_537_5853# DGND.t677 sky130_fd_pr__nfet_01v8 ad=0.0567 pd=0.69 as=0.063 ps=0.72 w=0.42 l=0.15
X882 a_1823_4943# a_1775_5206.t5 a_1733_5309# DVDD.t594 sky130_fd_pr__pfet_01v8 ad=0.0567 pd=0.69 as=0.063 ps=0.72 w=0.42 l=0.15
X883 a_4709_1929# a_4943_1653# a_4877_1679# DGND.t150 sky130_fd_pr__nfet_01v8 ad=0.195 pd=1.9 as=0.10725 ps=0.98 w=0.65 l=0.15
X884 a_6005_2223# a_5503_2767# a_5923_2223# DVDD.t27 sky130_fd_pr__pfet_01v8 ad=0.135 pd=1.27 as=0.26 ps=2.52 w=1 l=0.15
X885 a_3471_6031# a_1455_6031# a_3387_6031# DGND.t423 sky130_fd_pr__nfet_01v8 ad=0.0567 pd=0.69 as=0.0567 ps=0.69 w=0.42 l=0.15
X886 a_6412_5719# a_5779_4943# a_6219_5309# DVDD.t891 sky130_fd_pr__pfet_01v8 ad=0.0693 pd=0.75 as=0.06195 ps=0.715 w=0.42 l=0.15
X887 a_3523_3030# a_3891_3432# a_3849_3677# DGND.t858 sky130_fd_pr__nfet_01v8 ad=0.0567 pd=0.69 as=0.063 ps=0.72 w=0.42 l=0.15
X888 a_3471_2045# DGND.t910 a_2235_1256# DVDD.t85 sky130_fd_pr__pfet_01v8 ad=0.0567 pd=0.69 as=0.0567 ps=0.69 w=0.42 l=0.15
X889 a_975_3311# a_297_3017# DVDD.t696 DVDD.t695 sky130_fd_pr__pfet_01v8 ad=0.0567 pd=0.69 as=0.1092 ps=1.36 w=0.42 l=0.15
X890 a_4268_2767# a_3571_2767# a_4011_2767# DGND.t12 sky130_fd_pr__nfet_01v8 ad=0.0693 pd=0.75 as=0.06195 ps=0.715 w=0.42 l=0.15
X891 a_4457_743# a_5188_2223# DVDD.t175 DVDD.t174 sky130_fd_pr__pfet_01v8 ad=0.26 pd=2.52 as=0.26 ps=2.52 w=1 l=0.15
X892 a_4309_5309# a_3072_4399# DVDD.t925 DVDD.t924 sky130_fd_pr__pfet_01v8 ad=0.063 pd=0.72 as=0.1575 ps=1.59 w=0.42 l=0.15
X893 a_2907_2223# a_2045_2223# DVDD.t940 DVDD.t939 sky130_fd_pr__pfet_01v8 ad=0.0567 pd=0.69 as=0.1092 ps=1.36 w=0.42 l=0.15
X894 DVDD.t828 a_1692_4399# a_5311_4221# DVDD.t827 sky130_fd_pr__pfet_01v8 ad=0.0567 pd=0.69 as=0.0567 ps=0.69 w=0.42 l=0.15
X895 a_2263_957# a_1775_854# DVDD.t601 DVDD.t600 sky130_fd_pr__pfet_01v8 ad=0.0567 pd=0.69 as=0.1092 ps=1.36 w=0.42 l=0.15
X896 DVDD.t884 a_1329_6183# a_1539_6397# DVDD.t883 sky130_fd_pr__pfet_01v8 ad=0.0567 pd=0.69 as=0.0567 ps=0.69 w=0.42 l=0.15
X897 a_5075_1148# a_4625_749# DGND.t261 DGND.t260 sky130_fd_pr__nfet_01v8 ad=0.169 pd=1.82 as=0.169 ps=1.82 w=0.65 l=0.15
X898 a_5002_1174# a_4709_1929# DVDD.t423 DVDD.t422 sky130_fd_pr__pfet_01v8 ad=0.07665 pd=0.785 as=0.15835 ps=1.395 w=0.42 l=0.15
X899 a_4115_4765# a_4073_4625# a_3799_4118# DGND.t18 sky130_fd_pr__nfet_01v8 ad=0.0567 pd=0.69 as=0.0567 ps=0.69 w=0.42 l=0.15
X900 a_1823_3855# a_1775_4118# a_1733_4221# DVDD.t723 sky130_fd_pr__pfet_01v8 ad=0.0567 pd=0.69 as=0.063 ps=0.72 w=0.42 l=0.15
X901 a_883_591# a_395_854# DGND.t171 DGND.t170 sky130_fd_pr__nfet_01v8 ad=0.0567 pd=0.69 as=0.1092 ps=1.36 w=0.42 l=0.15
X902 a_4667_591# a_4535_854# DGND.t204 DGND.t203 sky130_fd_pr__nfet_01v8 ad=0.1092 pd=1.36 as=0.0567 ps=0.69 w=0.42 l=0.15
X903 a_395_5206.t1 a0.t10 a_1125_6895# DGND.t82 sky130_fd_pr__nfet_01v8 ad=0.169 pd=1.82 as=0.08775 ps=0.92 w=0.65 l=0.15
X904 a_2157_5719# a3.t9 a_3241_6895# DGND.t391 sky130_fd_pr__nfet_01v8 ad=0.169 pd=1.82 as=0.08775 ps=0.92 w=0.65 l=0.15
X905 a_4528_6575# a_627_5487# a_4456_6575# DVDD.t247 sky130_fd_pr__pfet_01v8 ad=0.0693 pd=0.75 as=0.0441 ps=0.63 w=0.42 l=0.15
X906 a_1125_3855# b0.t10 DGND.t893 DGND.t892 sky130_fd_pr__nfet_01v8 ad=0.08775 pd=0.92 as=0.169 ps=1.82 w=0.65 l=0.15
X907 a_4471_5487# a_3983_5608# DVDD.t685 DVDD.t684 sky130_fd_pr__pfet_01v8 ad=0.0567 pd=0.69 as=0.1092 ps=1.36 w=0.42 l=0.15
X908 a_5284_2589# a_4533_2449# a_5188_2223# DGND.t146 sky130_fd_pr__nfet_01v8 ad=0.0441 pd=0.63 as=0.0693 ps=0.75 w=0.42 l=0.15
X909 DVDD.t198 a2.t10 a_2235_5608# DVDD.t197 sky130_fd_pr__pfet_01v8 ad=0.26 pd=2.52 as=0.135 ps=1.27 w=1 l=0.15
X910 a_1421_2919# b3.t10 DVDD.t255 DVDD.t254 sky130_fd_pr__pfet_01v8 ad=0.135 pd=1.27 as=0.26 ps=2.52 w=1 l=0.15
X911 a_5587_3133# a_5545_2925# a_5503_2767# DVDD.t690 sky130_fd_pr__pfet_01v8 ad=0.0567 pd=0.69 as=0.0567 ps=0.69 w=0.42 l=0.15
X912 a_395_5206.t2 b1.t9 DVDD.t173 DVDD.t172 sky130_fd_pr__pfet_01v8 ad=0.135 pd=1.27 as=0.26 ps=2.52 w=1 l=0.15
X913 a_3747_6575# DVDD.t774 a_1775_6696# DVDD.t775 sky130_fd_pr__pfet_01v8 ad=0.0567 pd=0.69 as=0.0567 ps=0.69 w=0.42 l=0.15
X914 a_1067_5487# a_443_4943# DVDD.t710 DVDD.t709 sky130_fd_pr__pfet_01v8 ad=0.0567 pd=0.69 as=0.1092 ps=1.36 w=0.42 l=0.15
X915 a_4824_5487# DVDD.t772 a_4351_5206# DVDD.t773 sky130_fd_pr__pfet_01v8 ad=0.0441 pd=0.63 as=0.0693 ps=0.75 w=0.42 l=0.15
X916 a_4103_1501# a_3571_2767# DGND.t11 DGND.t10 sky130_fd_pr__nfet_01v8 ad=0.0567 pd=0.69 as=0.1092 ps=1.36 w=0.42 l=0.15
X917 DVDD.t212 a_1697_743# a_1907_957# DVDD.t211 sky130_fd_pr__pfet_01v8 ad=0.0567 pd=0.69 as=0.0567 ps=0.69 w=0.42 l=0.15
X918 a_2263_4943# a_1775_5206.t6 DGND.t342 DGND.t341 sky130_fd_pr__nfet_01v8 ad=0.0567 pd=0.69 as=0.1092 ps=1.36 w=0.42 l=0.15
X919 a_3941_4765# a_3609_4399# DGND.t275 DGND.t274 sky130_fd_pr__nfet_01v8 ad=0.063 pd=0.72 as=0.1596 ps=1.6 w=0.42 l=0.15
X920 a_1861_5807# b2.t10 DGND.t371 DGND.t370 sky130_fd_pr__nfet_01v8 ad=0.08775 pd=0.92 as=0.169 ps=1.82 w=0.65 l=0.15
X921 DGND.t224 a_1697_5095.t9 a_1907_4943# DGND.t223 sky130_fd_pr__nfet_01v8 ad=0.0567 pd=0.69 as=0.0567 ps=0.69 w=0.42 l=0.15
X922 a_4401_2589# a_4268_2767# DGND.t863 DGND.t862 sky130_fd_pr__nfet_01v8 ad=0.063 pd=0.72 as=0.1596 ps=1.6 w=0.42 l=0.15
X923 a_6000_6397# a_3387_6031# a_5928_6397# DVDD.t231 sky130_fd_pr__pfet_01v8 ad=0.0693 pd=0.75 as=0.0441 ps=0.63 w=0.42 l=0.15
X924 a_984_6183# a_627_5487# a_1067_5853# DGND.t229 sky130_fd_pr__nfet_01v8 ad=0.0693 pd=0.75 as=0.06195 ps=0.715 w=0.42 l=0.15
X925 a_2616_4943# a_1823_6575# P5.t1 DGND.t252 sky130_fd_pr__nfet_01v8 ad=0.0441 pd=0.63 as=0.0693 ps=0.75 w=0.42 l=0.15
X926 a_6644_4943# a_4399_4943# a_6572_4943# DGND.t112 sky130_fd_pr__nfet_01v8 ad=0.0693 pd=0.75 as=0.0441 ps=0.63 w=0.42 l=0.15
X927 a_4667_957# a_4625_749# a_1865_749# DVDD.t283 sky130_fd_pr__pfet_01v8 ad=0.0567 pd=0.69 as=0.0567 ps=0.69 w=0.42 l=0.15
X928 a_553_1679# a_219_1929# a_469_1929# DVDD.t863 sky130_fd_pr__pfet_01v8 ad=0.3 pd=2.6 as=0.26 ps=2.52 w=1 l=0.15
X929 DVDD.t23 a_2325_5713# a_2723_5487# DVDD.t22 sky130_fd_pr__pfet_01v8 ad=0.0567 pd=0.69 as=0.0567 ps=0.69 w=0.42 l=0.15
X930 a_5545_2925# a_4636_3311# DGND.t1 DGND.t0 sky130_fd_pr__nfet_01v8 ad=0.169 pd=1.82 as=0.169 ps=1.82 w=0.65 l=0.15
X931 a_3571_2767# a_3523_3030# a_3481_3133# DVDD.t143 sky130_fd_pr__pfet_01v8 ad=0.0567 pd=0.69 as=0.063 ps=0.72 w=0.42 l=0.15
X932 DGND.t806 a_2980_1135# a_5923_1135# DGND.t805 sky130_fd_pr__nfet_01v8 ad=0.08775 pd=0.92 as=0.08775 ps=0.92 w=0.65 l=0.15
X933 DVDD.t716 a1.t10 a_317_5095# DVDD.t252 sky130_fd_pr__pfet_01v8 ad=0.26 pd=2.52 as=0.135 ps=1.27 w=1 l=0.15
X934 a_6737_3855# b5.t9 DGND.t517 DGND.t516 sky130_fd_pr__nfet_01v8 ad=0.08775 pd=0.92 as=0.169 ps=1.82 w=0.65 l=0.15
X935 a_219_1929# a_259_1831# DGND.t403 DGND.t402 sky130_fd_pr__nfet_01v8 ad=0.08775 pd=0.92 as=0.169 ps=1.82 w=0.65 l=0.15
X936 a_3164_2223# a_2467_2223# a_2907_2589# DGND.t216 sky130_fd_pr__nfet_01v8 ad=0.0693 pd=0.75 as=0.06195 ps=0.715 w=0.42 l=0.15
X937 DGND.t847 a_757_6281# a_1079_4765# DGND.t846 sky130_fd_pr__nfet_01v8 ad=0.0567 pd=0.69 as=0.0567 ps=0.69 w=0.42 l=0.15
X938 a_3241_4943# b1.t10 DGND.t897 DGND.t896 sky130_fd_pr__nfet_01v8 ad=0.08775 pd=0.92 as=0.169 ps=1.82 w=0.65 l=0.15
X939 DVDD.t370 a_3813_3543# a_4023_3311# DVDD.t369 sky130_fd_pr__pfet_01v8 ad=0.0567 pd=0.69 as=0.0567 ps=0.69 w=0.42 l=0.15
X940 a_1508_1135# a_259_1831# a_1251_1501# DGND.t401 sky130_fd_pr__nfet_01v8 ad=0.0693 pd=0.75 as=0.06195 ps=0.715 w=0.42 l=0.15
X941 a_4287_4221# a_3072_3311# DVDD.t629 DVDD.t628 sky130_fd_pr__pfet_01v8 ad=0.06195 pd=0.715 as=0.0567 ps=0.69 w=0.42 l=0.15
X942 a_6047_1679# a_5779_4943# DGND.t840 DGND.t839 sky130_fd_pr__nfet_01v8 ad=0.1092 pd=1.36 as=0.0567 ps=0.69 w=0.42 l=0.15
X943 a_3609_4719# b3.t11 DGND.t110 DGND.t109 sky130_fd_pr__nfet_01v8 ad=0.08775 pd=0.92 as=0.169 ps=1.82 w=0.65 l=0.15
X944 a_5023_591# a_4535_854# DGND.t202 DGND.t201 sky130_fd_pr__nfet_01v8 ad=0.0567 pd=0.69 as=0.1092 ps=1.36 w=0.42 l=0.15
X945 a_1733_6941# a_1697_6807.t10 DGND.t38 DGND.t37 sky130_fd_pr__nfet_01v8 ad=0.063 pd=0.72 as=0.1596 ps=1.6 w=0.42 l=0.15
X946 a_4533_2449# b5.t10 DVDD.t752 DVDD.t751 sky130_fd_pr__pfet_01v8 ad=0.135 pd=1.27 as=0.26 ps=2.52 w=1 l=0.15
X947 a_2367_1135# a_2235_1256# DVDD.t358 DVDD.t357 sky130_fd_pr__pfet_01v8 ad=0.1092 pd=1.36 as=0.0567 ps=0.69 w=0.42 l=0.15
X948 a_3827_1679# a_2467_2223# DGND.t215 DGND.t214 sky130_fd_pr__nfet_01v8 ad=0.0567 pd=0.69 as=0.1092 ps=1.36 w=0.42 l=0.15
X949 a_4399_4943# a_4351_5206# a_4309_5309# DVDD.t264 sky130_fd_pr__pfet_01v8 ad=0.0567 pd=0.69 as=0.063 ps=0.72 w=0.42 l=0.15
X950 DVDD.t627 a_3072_3311# a_4712_4221# DVDD.t626 sky130_fd_pr__pfet_01v8 ad=0.1575 pd=1.59 as=0.0693 ps=0.75 w=0.42 l=0.15
X951 DGND.t476 a_961_1831# a_1171_1679# DGND.t475 sky130_fd_pr__nfet_01v8 ad=0.0567 pd=0.69 as=0.0567 ps=0.69 w=0.42 l=0.15
X952 DGND.t434 a_1125_3017# a_2907_2589# DGND.t433 sky130_fd_pr__nfet_01v8 ad=0.0567 pd=0.69 as=0.0567 ps=0.69 w=0.42 l=0.15
X953 DVDD.t90 a_2249_4631# a_2459_4399# DVDD.t89 sky130_fd_pr__pfet_01v8 ad=0.0567 pd=0.69 as=0.0567 ps=0.69 w=0.42 l=0.15
X954 a_6047_2045# a_1823_4943# a_4625_749# DVDD.t408 sky130_fd_pr__pfet_01v8 ad=0.0567 pd=0.69 as=0.0567 ps=0.69 w=0.42 l=0.15
X955 DVDD.t253 a3.t10 a_573_4105# DVDD.t252 sky130_fd_pr__pfet_01v8 ad=0.26 pd=2.52 as=0.135 ps=1.27 w=1 l=0.15
X956 P2.t1 a_984_6183# DVDD.t543 DVDD.t542 sky130_fd_pr__pfet_01v8 ad=0.26 pd=2.52 as=0.26 ps=2.52 w=1 l=0.15
X957 a_3072_4399# a_2375_4399# a_2815_4765# DGND.t419 sky130_fd_pr__nfet_01v8 ad=0.0693 pd=0.75 as=0.06195 ps=0.715 w=0.42 l=0.15
X958 a_3168_4399# a_2417_4625# a_3072_4399# DVDD.t76 sky130_fd_pr__pfet_01v8 ad=0.0441 pd=0.63 as=0.0693 ps=0.75 w=0.42 l=0.15
X959 a_1125_3017# a3.t11 a_1125_2767# DGND.t236 sky130_fd_pr__nfet_01v8 ad=0.169 pd=1.82 as=0.08775 ps=0.92 w=0.65 l=0.15
X960 a_711_5487# DGND.t911 a_627_5487# DVDD.t86 sky130_fd_pr__pfet_01v8 ad=0.0567 pd=0.69 as=0.0567 ps=0.69 w=0.42 l=0.15
X961 a_2688_5309# a_1775_5206.t7 a_2616_5309# DVDD.t364 sky130_fd_pr__pfet_01v8 ad=0.0693 pd=0.75 as=0.0441 ps=0.63 w=0.42 l=0.15
X962 DVDD.t19 a_4073_4625# a_4471_4399# DVDD.t18 sky130_fd_pr__pfet_01v8 ad=0.0567 pd=0.69 as=0.0567 ps=0.69 w=0.42 l=0.15
X963 a_443_591# a_395_854# a_353_957# DVDD.t181 sky130_fd_pr__pfet_01v8 ad=0.0567 pd=0.69 as=0.063 ps=0.72 w=0.42 l=0.15
X964 DVDD.t933 a_4457_743# a_5448_957# DVDD.t932 sky130_fd_pr__pfet_01v8 ad=0.1575 pd=1.59 as=0.0693 ps=0.75 w=0.42 l=0.15
X965 a_883_2223# a_317_2455# DVDD.t587 DVDD.t586 sky130_fd_pr__pfet_01v8 ad=0.06195 pd=0.715 as=0.0567 ps=0.69 w=0.42 l=0.15
X966 DGND.t418 a_2375_4399# a_5667_3855# DGND.t417 sky130_fd_pr__nfet_01v8 ad=0.0567 pd=0.69 as=0.0567 ps=0.69 w=0.42 l=0.15
X967 a_4847_1653# a_5095_1929# a_5345_1929# DVDD.t356 sky130_fd_pr__pfet_01v8 ad=0.3 pd=2.6 as=0.26 ps=2.52 w=1 l=0.15
X968 DVDD.t163 a_849_4105# a_2815_3311# DVDD.t162 sky130_fd_pr__pfet_01v8 ad=0.0567 pd=0.69 as=0.0567 ps=0.69 w=0.42 l=0.15
X969 DGND.t414 a_2244_2767# a_4252_1679# DGND.t413 sky130_fd_pr__nfet_01v8 ad=0.1176 pd=1.4 as=0.0693 ps=0.75 w=0.42 l=0.15
X970 a_1527_2045# a_961_1831# DVDD.t529 DVDD.t528 sky130_fd_pr__pfet_01v8 ad=0.06195 pd=0.715 as=0.0567 ps=0.69 w=0.42 l=0.15
X971 a_3471_6397# a_1455_6031# a_3387_6031# DVDD.t447 sky130_fd_pr__pfet_01v8 ad=0.0567 pd=0.69 as=0.0567 ps=0.69 w=0.42 l=0.15
X972 a_2723_1501# a_1784_1679# DGND.t327 DGND.t326 sky130_fd_pr__nfet_01v8 ad=0.06195 pd=0.715 as=0.0567 ps=0.69 w=0.42 l=0.15
X973 DVDD.t585 a_317_2455# a_1308_2223# DVDD.t584 sky130_fd_pr__pfet_01v8 ad=0.1575 pd=1.59 as=0.0693 ps=0.75 w=0.42 l=0.15
X974 DGND.t407 a_1865_4013# a_2263_3855# DGND.t406 sky130_fd_pr__nfet_01v8 ad=0.0567 pd=0.69 as=0.0567 ps=0.69 w=0.42 l=0.15
X975 a_895_1135# DVDD.t770 a_259_1831# DVDD.t771 sky130_fd_pr__pfet_01v8 ad=0.0567 pd=0.69 as=0.0567 ps=0.69 w=0.42 l=0.15
X976 a_2285_4399# a_2249_4631# DVDD.t88 DVDD.t87 sky130_fd_pr__pfet_01v8 ad=0.063 pd=0.72 as=0.1575 ps=1.59 w=0.42 l=0.15
X977 a_2688_4221# a_1775_4118# a_2616_4221# DVDD.t722 sky130_fd_pr__pfet_01v8 ad=0.0693 pd=0.75 as=0.0441 ps=0.63 w=0.42 l=0.15
X978 a_5227_3855# a_4031_5487# a_5137_4221# DVDD.t385 sky130_fd_pr__pfet_01v8 ad=0.0567 pd=0.69 as=0.063 ps=0.72 w=0.42 l=0.15
X979 a_849_3017# b4.t9 DVDD.t401 DVDD.t400 sky130_fd_pr__pfet_01v8 ad=0.135 pd=1.27 as=0.26 ps=2.52 w=1 l=0.15
X980 a_5448_957# a_4535_854# a_5376_957# DVDD.t220 sky130_fd_pr__pfet_01v8 ad=0.0693 pd=0.75 as=0.0441 ps=0.63 w=0.42 l=0.15
X981 a_527_5309# a_395_5206.t9 DVDD.t619 DVDD.t618 sky130_fd_pr__pfet_01v8 ad=0.1092 pd=1.36 as=0.0567 ps=0.69 w=0.42 l=0.15
X982 DGND.t879 a_4457_743# a_4667_591# DGND.t878 sky130_fd_pr__nfet_01v8 ad=0.0567 pd=0.69 as=0.0567 ps=0.69 w=0.42 l=0.15
X983 a_1539_6031# a_1497_6189# a_1455_6031# DGND.t668 sky130_fd_pr__nfet_01v8 ad=0.0567 pd=0.69 as=0.0567 ps=0.69 w=0.42 l=0.15
X984 a_5943_2767# a_5227_3855# DGND.t68 DGND.t67 sky130_fd_pr__nfet_01v8 ad=0.0567 pd=0.69 as=0.1092 ps=1.36 w=0.42 l=0.15
X985 DVDD.t483 DGND.t912 a_2263_6575# DVDD.t482 sky130_fd_pr__pfet_01v8 ad=0.0567 pd=0.69 as=0.0567 ps=0.69 w=0.42 l=0.15
X986 a_1631_3133# a_849_3017# DVDD.t488 DVDD.t487 sky130_fd_pr__pfet_01v8 ad=0.1092 pd=1.36 as=0.0567 ps=0.69 w=0.42 l=0.15
X987 a_297_2767# b5.t11 DGND.t723 DGND.t722 sky130_fd_pr__nfet_01v8 ad=0.08775 pd=0.92 as=0.169 ps=1.82 w=0.65 l=0.15
X988 a_1775_854# a_3847_3855# a_4401_2589# DGND.t794 sky130_fd_pr__nfet_01v8 ad=0.0567 pd=0.69 as=0.063 ps=0.72 w=0.42 l=0.15
X989 a_4379_3677# a_3813_3543# DGND.t346 DGND.t345 sky130_fd_pr__nfet_01v8 ad=0.06195 pd=0.715 as=0.0567 ps=0.69 w=0.42 l=0.15
X990 DGND.t873 a_3072_4399# a_4483_4943# DGND.t872 sky130_fd_pr__nfet_01v8 ad=0.0567 pd=0.69 as=0.0567 ps=0.69 w=0.42 l=0.15
X991 a_905_4765# a_757_6281# DGND.t845 DGND.t844 sky130_fd_pr__nfet_01v8 ad=0.063 pd=0.72 as=0.1596 ps=1.6 w=0.42 l=0.15
X992 DVDD.t615 a4.t10 a_2249_4631# DVDD.t614 sky130_fd_pr__pfet_01v8 ad=0.26 pd=2.52 as=0.135 ps=1.27 w=1 l=0.15
X993 DGND.t429 a_1865_749# a_2263_591# DGND.t428 sky130_fd_pr__nfet_01v8 ad=0.0567 pd=0.69 as=0.0567 ps=0.69 w=0.42 l=0.15
X994 a_5223_1501# a_5075_1148# a_4860_1367# DGND.t139 sky130_fd_pr__nfet_01v8 ad=0.0693 pd=0.75 as=0.09975 ps=0.895 w=0.42 l=0.15
X995 a_5002_1501# a_4709_1929# DGND.t398 DGND.t397 sky130_fd_pr__nfet_01v8 ad=0.0693 pd=0.75 as=0.11285 ps=1.045 w=0.42 l=0.15
X996 DVDD.t645 a_2341_2455# a_2551_2223# DVDD.t644 sky130_fd_pr__pfet_01v8 ad=0.0567 pd=0.69 as=0.0567 ps=0.69 w=0.42 l=0.15
X997 a_5837_1831# a_5503_2767# a_5943_3133# DVDD.t26 sky130_fd_pr__pfet_01v8 ad=0.0693 pd=0.75 as=0.06195 ps=0.715 w=0.42 l=0.15
X998 P3.t1 a_1775_6696# a_4103_6575# DVDD.t471 sky130_fd_pr__pfet_01v8 ad=0.0693 pd=0.75 as=0.06195 ps=0.715 w=0.42 l=0.15
X999 a_5265_5807# b1.t11 DGND.t899 DGND.t898 sky130_fd_pr__nfet_01v8 ad=0.08775 pd=0.92 as=0.169 ps=1.82 w=0.65 l=0.15
X1000 DVDD.t836 a_3905_5719# a_4115_5487# DVDD.t835 sky130_fd_pr__pfet_01v8 ad=0.0567 pd=0.69 as=0.0567 ps=0.69 w=0.42 l=0.15
X1001 DVDD.t343 a_317_743# a_1308_957# DVDD.t342 sky130_fd_pr__pfet_01v8 ad=0.1575 pd=1.59 as=0.0693 ps=0.75 w=0.42 l=0.15
X1002 a_4023_3677# a_3891_3432# DGND.t857 DGND.t856 sky130_fd_pr__nfet_01v8 ad=0.1092 pd=1.36 as=0.0567 ps=0.69 w=0.42 l=0.15
X1003 a_997_1679# a_961_1831# DGND.t474 DGND.t473 sky130_fd_pr__nfet_01v8 ad=0.063 pd=0.72 as=0.1596 ps=1.6 w=0.42 l=0.15
X1004 a_317_743# a_2980_1135# DGND.t804 DGND.t803 sky130_fd_pr__nfet_01v8 ad=0.169 pd=1.82 as=0.169 ps=1.82 w=0.65 l=0.15
X1005 a_4436_3133# a_3523_3030# a_4364_3133# DVDD.t142 sky130_fd_pr__pfet_01v8 ad=0.0693 pd=0.75 as=0.0441 ps=0.63 w=0.42 l=0.15
X1006 a_1865_749# a_4535_854# a_4493_957# DVDD.t219 sky130_fd_pr__pfet_01v8 ad=0.0567 pd=0.69 as=0.063 ps=0.72 w=0.42 l=0.15
X1007 a_1823_4943# a_1775_5206.t8 a_1733_4943# DGND.t343 sky130_fd_pr__nfet_01v8 ad=0.0567 pd=0.69 as=0.063 ps=0.72 w=0.42 l=0.15
X1008 a_353_957# a_317_743# DVDD.t341 DVDD.t340 sky130_fd_pr__pfet_01v8 ad=0.063 pd=0.72 as=0.1575 ps=1.59 w=0.42 l=0.15
X1009 a_6412_5719# a_5779_4943# a_6219_4943# DGND.t838 sky130_fd_pr__nfet_01v8 ad=0.0693 pd=0.75 as=0.06195 ps=0.715 w=0.42 l=0.15
X1010 a_1860_4765# a_947_4520# a_1788_4765# DGND.t267 sky130_fd_pr__nfet_01v8 ad=0.0693 pd=0.75 as=0.0441 ps=0.63 w=0.42 l=0.15
X1011 DVDD.t899 a_757_6281# a_1860_4399# DVDD.t898 sky130_fd_pr__pfet_01v8 ad=0.1575 pd=1.59 as=0.0693 ps=0.75 w=0.42 l=0.15
X1012 a_445_3311# a_409_3543# DVDD.t730 DVDD.t729 sky130_fd_pr__pfet_01v8 ad=0.063 pd=0.72 as=0.1575 ps=1.59 w=0.42 l=0.15
X1013 a_4804_3311# a_3891_3432# a_4732_3311# DVDD.t906 sky130_fd_pr__pfet_01v8 ad=0.0693 pd=0.75 as=0.0441 ps=0.63 w=0.42 l=0.15
X1014 a_2377_2223# a_2341_2455# DVDD.t643 DVDD.t642 sky130_fd_pr__pfet_01v8 ad=0.063 pd=0.72 as=0.1575 ps=1.59 w=0.42 l=0.15
X1015 a_4309_4943# a_3072_4399# DGND.t871 DGND.t870 sky130_fd_pr__nfet_01v8 ad=0.063 pd=0.72 as=0.1596 ps=1.6 w=0.42 l=0.15
X1016 a_1308_957# a_395_854# a_1236_957# DVDD.t180 sky130_fd_pr__pfet_01v8 ad=0.0693 pd=0.75 as=0.0441 ps=0.63 w=0.42 l=0.15
X1017 a_469_1929# a_355_1653# DVDD.t705 DVDD.t704 sky130_fd_pr__pfet_01v8 ad=0.135 pd=1.27 as=0.135 ps=1.27 w=1 l=0.15
X1018 a_573_4719# b0.t11 DGND.t895 DGND.t894 sky130_fd_pr__nfet_01v8 ad=0.08775 pd=0.92 as=0.169 ps=1.82 w=0.65 l=0.15
X1019 a_1952_1679# a_1039_1942# a_1880_1679# DGND.t526 sky130_fd_pr__nfet_01v8 ad=0.0693 pd=0.75 as=0.0441 ps=0.63 w=0.42 l=0.15
X1020 a_4287_4221# a_3799_4118# DVDD.t3 DVDD.t2 sky130_fd_pr__pfet_01v8 ad=0.0567 pd=0.69 as=0.1092 ps=1.36 w=0.42 l=0.15
X1021 P11.t2 a_1823_3855# a_2493_1679# DGND.t291 sky130_fd_pr__nfet_01v8 ad=0.25025 pd=1.42 as=0.08775 ps=0.92 w=0.65 l=0.15
X1022 a_2367_5487# a_2235_5608# DVDD.t553 DVDD.t552 sky130_fd_pr__pfet_01v8 ad=0.1092 pd=1.36 as=0.0567 ps=0.69 w=0.42 l=0.15
X1023 DVDD.t625 a_3072_3311# a_3931_4221# DVDD.t624 sky130_fd_pr__pfet_01v8 ad=0.0567 pd=0.69 as=0.0567 ps=0.69 w=0.42 l=0.15
X1024 a_2815_3677# a_2249_3543# DGND.t438 DGND.t437 sky130_fd_pr__nfet_01v8 ad=0.06195 pd=0.715 as=0.0567 ps=0.69 w=0.42 l=0.15
X1025 a_2367_1135# DVDD.t768 a_1775_4118# DVDD.t769 sky130_fd_pr__pfet_01v8 ad=0.0567 pd=0.69 as=0.0567 ps=0.69 w=0.42 l=0.15
X1026 a_6756_1679# a_1823_4943# a_6412_4007# DGND.t385 sky130_fd_pr__nfet_01v8 ad=0.0441 pd=0.63 as=0.0693 ps=0.75 w=0.42 l=0.15
X1027 a_763_1256# a_1039_1942# a_997_1679# DGND.t525 sky130_fd_pr__nfet_01v8 ad=0.0567 pd=0.69 as=0.063 ps=0.72 w=0.42 l=0.15
X1028 a_2375_4399# a_2327_4520# a_2285_4399# DVDD.t45 sky130_fd_pr__pfet_01v8 ad=0.0567 pd=0.69 as=0.063 ps=0.72 w=0.42 l=0.15
X1029 a_1236_5309# DVDD.t766 P1.t2 DVDD.t767 sky130_fd_pr__pfet_01v8 ad=0.0441 pd=0.63 as=0.0693 ps=0.75 w=0.42 l=0.15
X1030 P0.t1 a_248_4631# DVDD.t913 DVDD.t912 sky130_fd_pr__pfet_01v8 ad=0.26 pd=2.52 as=0.26 ps=2.52 w=1 l=0.15
X1031 DGND.t711 a_3537_6807# a_3747_6941# DGND.t710 sky130_fd_pr__nfet_01v8 ad=0.0567 pd=0.69 as=0.0567 ps=0.69 w=0.42 l=0.15
X1032 DGND.t554 DGND.t552 a_1067_5853# DGND.t553 sky130_fd_pr__nfet_01v8 ad=0.0567 pd=0.69 as=0.0567 ps=0.69 w=0.42 l=0.15
X1033 a_619_3677# a_297_3017# DGND.t663 DGND.t662 sky130_fd_pr__nfet_01v8 ad=0.1092 pd=1.36 as=0.0567 ps=0.69 w=0.42 l=0.15
X1034 a_317_2455# a_297_4105# DVDD.t758 DVDD.t757 sky130_fd_pr__pfet_01v8 ad=0.26 pd=2.52 as=0.26 ps=2.52 w=1 l=0.15
X1035 a_4640_4221# a_995_4399# a_4544_3855# DVDD.t137 sky130_fd_pr__pfet_01v8 ad=0.0441 pd=0.63 as=0.0693 ps=0.75 w=0.42 l=0.15
X1036 a_1907_957# a_1865_749# a_485_749# DVDD.t454 sky130_fd_pr__pfet_01v8 ad=0.0567 pd=0.69 as=0.0567 ps=0.69 w=0.42 l=0.15
X1037 a_2551_2589# a_2045_2223# DGND.t887 DGND.t886 sky130_fd_pr__nfet_01v8 ad=0.1092 pd=1.36 as=0.0567 ps=0.69 w=0.42 l=0.15
X1038 a_4456_6941# DVDD.t968 P3.t2 DGND.t736 sky130_fd_pr__nfet_01v8 ad=0.0441 pd=0.63 as=0.0693 ps=0.75 w=0.42 l=0.15
X1039 DVDD.t617 a4.t11 a_297_3017# DVDD.t616 sky130_fd_pr__pfet_01v8 ad=0.26 pd=2.52 as=0.135 ps=1.27 w=1 l=0.15
X1040 DGND.t412 a_2244_2767# a_3471_1679# DGND.t411 sky130_fd_pr__nfet_01v8 ad=0.0567 pd=0.69 as=0.0567 ps=0.69 w=0.42 l=0.15
X1041 a_5653_5095# a_5227_3855# a_5667_4221# DVDD.t67 sky130_fd_pr__pfet_01v8 ad=0.0693 pd=0.75 as=0.06195 ps=0.715 w=0.42 l=0.15
X1042 a_995_4399# a_947_4520# a_905_4765# DGND.t266 sky130_fd_pr__nfet_01v8 ad=0.0567 pd=0.69 as=0.063 ps=0.72 w=0.42 l=0.15
X1043 a_5873_1679# a_5837_1831# DGND.t812 DGND.t811 sky130_fd_pr__nfet_01v8 ad=0.063 pd=0.72 as=0.1596 ps=1.6 w=0.42 l=0.15
X1044 a_1527_2045# a_1039_1942# DVDD.t578 DVDD.t577 sky130_fd_pr__pfet_01v8 ad=0.0567 pd=0.69 as=0.1092 ps=1.36 w=0.42 l=0.15
X1045 a_2723_5853# a_2157_5719# DGND.t354 DGND.t353 sky130_fd_pr__nfet_01v8 ad=0.06195 pd=0.715 as=0.0567 ps=0.69 w=0.42 l=0.15
X1046 a_3983_4520# a1.t11 a_5265_4719# DGND.t684 sky130_fd_pr__nfet_01v8 ad=0.169 pd=1.82 as=0.08775 ps=0.92 w=0.65 l=0.15
X1047 a_2723_1501# a_2235_1256# DGND.t335 DGND.t334 sky130_fd_pr__nfet_01v8 ad=0.0567 pd=0.69 as=0.1092 ps=1.36 w=0.42 l=0.15
X1048 a_5311_3855# a_4031_5487# DGND.t362 DGND.t361 sky130_fd_pr__nfet_01v8 ad=0.1092 pd=1.36 as=0.0567 ps=0.69 w=0.42 l=0.15
X1049 DVDD.t200 a2.t11 a_3813_3543# DVDD.t199 sky130_fd_pr__pfet_01v8 ad=0.26 pd=2.52 as=0.135 ps=1.27 w=1 l=0.15
X1050 a_4493_957# a_4457_743# DVDD.t931 DVDD.t930 sky130_fd_pr__pfet_01v8 ad=0.063 pd=0.72 as=0.1575 ps=1.59 w=0.42 l=0.15
X1051 DGND.t735 DVDD.t969 a_1251_1501# DGND.t734 sky130_fd_pr__nfet_01v8 ad=0.0567 pd=0.69 as=0.0567 ps=0.69 w=0.42 l=0.15
X1052 DVDD.t83 a0.t11 a_3983_5608# DVDD.t82 sky130_fd_pr__pfet_01v8 ad=0.26 pd=2.52 as=0.135 ps=1.27 w=1 l=0.15
X1053 a_527_5309# DVDD.t764 a_443_4943# DVDD.t765 sky130_fd_pr__pfet_01v8 ad=0.0567 pd=0.69 as=0.0567 ps=0.69 w=0.42 l=0.15
X1054 a_1907_3855# a_1865_4013# a_1823_3855# DGND.t405 sky130_fd_pr__nfet_01v8 ad=0.0567 pd=0.69 as=0.0567 ps=0.69 w=0.42 l=0.15
X1055 a_3573_6941# a_3537_6807# DGND.t709 DGND.t708 sky130_fd_pr__nfet_01v8 ad=0.063 pd=0.72 as=0.1596 ps=1.6 w=0.42 l=0.15
X1056 a_501_5719# a_1455_6031# a_1895_6031# DGND.t422 sky130_fd_pr__nfet_01v8 ad=0.0693 pd=0.75 as=0.06195 ps=0.715 w=0.42 l=0.15
X1057 a_3827_6031# a_3261_6183# DGND.t496 DGND.t495 sky130_fd_pr__nfet_01v8 ad=0.06195 pd=0.715 as=0.0567 ps=0.69 w=0.42 l=0.15
X1058 DGND.t304 a_573_4105# a_1987_2767# DGND.t303 sky130_fd_pr__nfet_01v8 ad=0.0567 pd=0.69 as=0.0567 ps=0.69 w=0.42 l=0.15
X1059 a_2781_2767# b2.t11 DGND.t373 DGND.t372 sky130_fd_pr__nfet_01v8 ad=0.08775 pd=0.92 as=0.169 ps=1.82 w=0.65 l=0.15
X1060 a_3827_2045# a_2244_2767# DVDD.t435 DVDD.t434 sky130_fd_pr__pfet_01v8 ad=0.06195 pd=0.715 as=0.0567 ps=0.69 w=0.42 l=0.15
X1061 a_5356_2589# a_3847_3855# a_5284_2589# DGND.t793 sky130_fd_pr__nfet_01v8 ad=0.0693 pd=0.75 as=0.0441 ps=0.63 w=0.42 l=0.15
X1062 a_2412_3133# a_849_3017# a_2340_3133# DVDD.t486 sky130_fd_pr__pfet_01v8 ad=0.0693 pd=0.75 as=0.0441 ps=0.63 w=0.42 l=0.15
X1063 a_5345_1929# a_1697_743# DVDD.t210 DVDD.t209 sky130_fd_pr__pfet_01v8 ad=0.135 pd=1.27 as=0.135 ps=1.27 w=1 l=0.15
X1064 a_1539_6397# a_1497_6189# a_1455_6031# DVDD.t700 sky130_fd_pr__pfet_01v8 ad=0.0567 pd=0.69 as=0.0567 ps=0.69 w=0.42 l=0.15
X1065 a_2459_4765# a_2327_4520# DGND.t46 DGND.t45 sky130_fd_pr__nfet_01v8 ad=0.1092 pd=1.36 as=0.0567 ps=0.69 w=0.42 l=0.15
X1066 a_1880_2045# DGND.t913 a_1784_1679# DVDD.t484 sky130_fd_pr__pfet_01v8 ad=0.0441 pd=0.63 as=0.0693 ps=0.75 w=0.42 l=0.15
X1067 a_537_5487# a_501_5719# DVDD.t96 DVDD.t95 sky130_fd_pr__pfet_01v8 ad=0.063 pd=0.72 as=0.1575 ps=1.59 w=0.42 l=0.15
X1068 DVDD.t923 a_3072_4399# a_5264_5309# DVDD.t922 sky130_fd_pr__pfet_01v8 ad=0.1575 pd=1.59 as=0.0693 ps=0.75 w=0.42 l=0.15
X1069 a_3297_1679# a_2244_2767# DGND.t410 DGND.t409 sky130_fd_pr__nfet_01v8 ad=0.063 pd=0.72 as=0.1596 ps=1.6 w=0.42 l=0.15
X1070 DVDD.t527 a_961_1831# a_1952_2045# DVDD.t526 sky130_fd_pr__pfet_01v8 ad=0.1575 pd=1.59 as=0.0693 ps=0.75 w=0.42 l=0.15
X1071 a_4621_6031# b4.t10 DGND.t519 DGND.t518 sky130_fd_pr__nfet_01v8 ad=0.08775 pd=0.92 as=0.169 ps=1.82 w=0.65 l=0.15
X1072 a_4896_5487# a_3983_5608# a_4824_5487# DVDD.t683 sky130_fd_pr__pfet_01v8 ad=0.0693 pd=0.75 as=0.0441 ps=0.63 w=0.42 l=0.15
X1073 a_4379_3677# a_3891_3432# DGND.t855 DGND.t854 sky130_fd_pr__nfet_01v8 ad=0.0567 pd=0.69 as=0.1092 ps=1.36 w=0.42 l=0.15
X1074 a_395_2344# a_297_3017# a_445_3311# DVDD.t694 sky130_fd_pr__pfet_01v8 ad=0.0567 pd=0.69 as=0.063 ps=0.72 w=0.42 l=0.15
X1075 a_2263_591# a_1775_854# DGND.t543 DGND.t542 sky130_fd_pr__nfet_01v8 ad=0.0567 pd=0.69 as=0.1092 ps=1.36 w=0.42 l=0.15
X1076 a_1907_6575# DGND.t914 a_1823_6575# DVDD.t485 sky130_fd_pr__pfet_01v8 ad=0.0567 pd=0.69 as=0.0567 ps=0.69 w=0.42 l=0.15
X1077 a_3261_6183# a_3517_5487# DGND.t44 DGND.t43 sky130_fd_pr__nfet_01v8 ad=0.169 pd=1.82 as=0.169 ps=1.82 w=0.65 l=0.15
X1078 DGND.t325 a_1784_1679# a_3148_1501# DGND.t324 sky130_fd_pr__nfet_01v8 ad=0.1176 pd=1.4 as=0.0693 ps=0.75 w=0.42 l=0.15
X1079 a_2467_2223# a_2045_2223# a_2377_2223# DVDD.t938 sky130_fd_pr__pfet_01v8 ad=0.0567 pd=0.69 as=0.063 ps=0.72 w=0.42 l=0.15
X1080 a_4399_4943# a_4351_5206# a_4309_4943# DGND.t246 sky130_fd_pr__nfet_01v8 ad=0.0567 pd=0.69 as=0.063 ps=0.72 w=0.42 l=0.15
X1081 a_883_2223# a_395_2344# DVDD.t506 DVDD.t505 sky130_fd_pr__pfet_01v8 ad=0.0567 pd=0.69 as=0.1092 ps=1.36 w=0.42 l=0.15
X1082 a_1631_3133# a_573_4105# a_1039_1942# DVDD.t327 sky130_fd_pr__pfet_01v8 ad=0.0567 pd=0.69 as=0.0567 ps=0.69 w=0.42 l=0.15
X1083 DVDD.t208 a_1697_743# a_2688_957# DVDD.t207 sky130_fd_pr__pfet_01v8 ad=0.1575 pd=1.59 as=0.0693 ps=0.75 w=0.42 l=0.15
X1084 a_4544_3855# a_3847_3855# a_4287_3855# DGND.t792 sky130_fd_pr__nfet_01v8 ad=0.0693 pd=0.75 as=0.06195 ps=0.715 w=0.42 l=0.15
X1085 a_4528_1501# a_3571_2767# a_4456_1501# DGND.t9 sky130_fd_pr__nfet_01v8 ad=0.0693 pd=0.75 as=0.0441 ps=0.63 w=0.42 l=0.15
X1086 a_2688_4943# a_1775_5206.t9 a_2616_4943# DGND.t724 sky130_fd_pr__nfet_01v8 ad=0.0693 pd=0.75 as=0.0441 ps=0.63 w=0.42 l=0.15
X1087 a_1435_4399# a_947_4520# DVDD.t291 DVDD.t290 sky130_fd_pr__pfet_01v8 ad=0.0567 pd=0.69 as=0.1092 ps=1.36 w=0.42 l=0.15
X1088 a_5863_5309# a_5821_5101# a_5779_4943# DVDD.t843 sky130_fd_pr__pfet_01v8 ad=0.0567 pd=0.69 as=0.0567 ps=0.69 w=0.42 l=0.15
X1089 P6.t1 a_6412_4007# DVDD.t421 DVDD.t420 sky130_fd_pr__pfet_01v8 ad=0.26 pd=2.52 as=0.26 ps=2.52 w=1 l=0.15
X1090 a_4732_3677# DVDD.t970 a_4636_3311# DGND.t733 sky130_fd_pr__nfet_01v8 ad=0.0441 pd=0.63 as=0.0693 ps=0.75 w=0.42 l=0.15
X1091 a_4268_2767# a_3571_2767# a_4011_3133# DVDD.t9 sky130_fd_pr__pfet_01v8 ad=0.0693 pd=0.75 as=0.06195 ps=0.715 w=0.42 l=0.15
X1092 a_4031_5487# a_3983_5608# a_3941_5487# DVDD.t682 sky130_fd_pr__pfet_01v8 ad=0.0567 pd=0.69 as=0.063 ps=0.72 w=0.42 l=0.15
X1093 DGND.t273 a_3609_4399# a_4896_4765# DGND.t272 sky130_fd_pr__nfet_01v8 ad=0.1176 pd=1.4 as=0.0693 ps=0.75 w=0.42 l=0.15
X1094 a_3655_2767# a_2375_3311# a_3571_2767# DGND.t461 sky130_fd_pr__nfet_01v8 ad=0.0567 pd=0.69 as=0.0567 ps=0.69 w=0.42 l=0.15
X1095 a_1692_4399# a_995_4399# a_1435_4765# DGND.t127 sky130_fd_pr__nfet_01v8 ad=0.0693 pd=0.75 as=0.06195 ps=0.715 w=0.42 l=0.15
X1096 a_1788_4399# a_1037_4625# a_1692_4399# DVDD.t745 sky130_fd_pr__pfet_01v8 ad=0.0441 pd=0.63 as=0.0693 ps=0.75 w=0.42 l=0.15
X1097 a_2688_957# a_1775_854# a_2616_957# DVDD.t599 sky130_fd_pr__pfet_01v8 ad=0.0693 pd=0.75 as=0.0441 ps=0.63 w=0.42 l=0.15
X1098 a_3747_1501# DVDD.t971 a_3663_1135# DGND.t732 sky130_fd_pr__nfet_01v8 ad=0.0567 pd=0.69 as=0.0567 ps=0.69 w=0.42 l=0.15
X1099 DGND.t190 a_1697_743# a_1907_591# DGND.t189 sky130_fd_pr__nfet_01v8 ad=0.0567 pd=0.69 as=0.0567 ps=0.69 w=0.42 l=0.15
X1100 DVDD.t763 DVDD.t761 a_4103_6575# DVDD.t762 sky130_fd_pr__pfet_01v8 ad=0.0567 pd=0.69 as=0.0567 ps=0.69 w=0.42 l=0.15
X1101 a_527_4943# a_395_5206.t10 DGND.t376 DGND.t375 sky130_fd_pr__nfet_01v8 ad=0.1092 pd=1.36 as=0.0567 ps=0.69 w=0.42 l=0.15
X1102 a_1125_3017# b4.t11 DVDD.t569 DVDD.t568 sky130_fd_pr__pfet_01v8 ad=0.135 pd=1.27 as=0.26 ps=2.52 w=1 l=0.15
X1103 a_4667_591# a_4625_749# a_1865_749# DGND.t259 sky130_fd_pr__nfet_01v8 ad=0.0567 pd=0.69 as=0.0567 ps=0.69 w=0.42 l=0.15
X1104 a_3747_6575# a_627_5487# DVDD.t246 DVDD.t245 sky130_fd_pr__pfet_01v8 ad=0.1092 pd=1.36 as=0.0567 ps=0.69 w=0.42 l=0.15
X1105 a_1784_1679# a_763_1256# a_1527_1679# DGND.t284 sky130_fd_pr__nfet_01v8 ad=0.0693 pd=0.75 as=0.06195 ps=0.715 w=0.42 l=0.15
X1106 a_2263_6941# a_1697_6807.t11 DGND.t40 DGND.t39 sky130_fd_pr__nfet_01v8 ad=0.06195 pd=0.715 as=0.0567 ps=0.69 w=0.42 l=0.15
X1107 a_4471_5853# a_3905_5719# DGND.t781 DGND.t780 sky130_fd_pr__nfet_01v8 ad=0.06195 pd=0.715 as=0.0567 ps=0.69 w=0.42 l=0.15
X1108 a_4625_749# a_5779_4943# a_5873_1679# DGND.t837 sky130_fd_pr__nfet_01v8 ad=0.0567 pd=0.69 as=0.063 ps=0.72 w=0.42 l=0.15
X1109 DGND.t510 a_553_1679# a_2243_1929# DGND.t509 sky130_fd_pr__nfet_01v8 ad=0.08775 pd=0.92 as=0.08775 ps=0.92 w=0.65 l=0.15
X1110 a_2815_3677# a_2327_3432# DGND.t184 DGND.t183 sky130_fd_pr__nfet_01v8 ad=0.0567 pd=0.69 as=0.1092 ps=1.36 w=0.42 l=0.15
X1111 a_4931_2223# a_3847_3855# DVDD.t848 DVDD.t847 sky130_fd_pr__pfet_01v8 ad=0.0567 pd=0.69 as=0.1092 ps=1.36 w=0.42 l=0.15
R0 DVDD.n978 DVDD.t31 842.073
R1 DVDD.n995 DVDD.t604 842.073
R2 DVDD.n1055 DVDD.t314 842.073
R3 DVDD.n911 DVDD.t427 842.073
R4 DVDD.n746 DVDD.t263 842.073
R5 DVDD.n1106 DVDD.t591 708.218
R6 DVDD.n907 DVDD.t341 708.218
R7 DVDD.n178 DVDD.t742 703.981
R8 DVDD.n219 DVDD.t663 703.981
R9 DVDD.n359 DVDD.t539 703.981
R10 DVDD.n465 DVDD.t378 703.981
R11 DVDD.n506 DVDD.t96 703.981
R12 DVDD.n508 DVDD.t62 703.981
R13 DVDD.n538 DVDD.t631 703.981
R14 DVDD.n629 DVDD.t301 703.981
R15 DVDD.n675 DVDD.t132 703.981
R16 DVDD.n128 DVDD.t730 703.981
R17 DVDD.n1147 DVDD.t464 703.981
R18 DVDD.n116 DVDD.t641 703.981
R19 DVDD.n959 DVDD.t871 703.981
R20 DVDD.n1039 DVDD.t437 703.981
R21 DVDD.n946 DVDD.t915 703.981
R22 DVDD.n1063 DVDD.t643 703.981
R23 DVDD.n1092 DVDD.t531 703.981
R24 DVDD.n785 DVDD.t655 703.981
R25 DVDD.n811 DVDD.t931 703.981
R26 DVDD.n866 DVDD.t349 703.981
R27 DVDD.n718 DVDD.t218 703.981
R28 DVDD.n968 DVDD.t869 703.402
R29 DVDD.n164 DVDD.t535 703.306
R30 DVDD.n272 DVDD.t407 702.926
R31 DVDD.n378 DVDD.t925 702.926
R32 DVDD.n527 DVDD.t88 702.926
R33 DVDD.n79 DVDD.t376 702.926
R34 DVDD.n899 DVDD.t52 702.926
R35 DVDD.n251 DVDD.t545 699.629
R36 DVDD.n276 DVDD.t890 699.629
R37 DVDD.n382 DVDD.t840 699.629
R38 DVDD.n475 DVDD.t81 699.629
R39 DVDD.n599 DVDD.t832 699.629
R40 DVDD.n696 DVDD.t901 699.629
R41 DVDD.n86 DVDD.t675 699.629
R42 DVDD.n46 DVDD.t322 699.629
R43 DVDD.n188 DVDD.t549 697.465
R44 DVDD.n225 DVDD.t738 697.465
R45 DVDD.n337 DVDD.t661 697.465
R46 DVDD.n260 DVDD.t886 697.465
R47 DVDD.n391 DVDD.t382 697.465
R48 DVDD.n423 DVDD.t838 697.465
R49 DVDD.n481 DVDD.t64 697.465
R50 DVDD.n605 DVDD.t627 697.465
R51 DVDD.n650 DVDD.t128 697.465
R52 DVDD.n60 DVDD.t677 697.465
R53 DVDD.n5 DVDD.t326 697.465
R54 DVDD.n1133 DVDD.t732 697.465
R55 DVDD.n1037 DVDD.t647 697.465
R56 DVDD.n1019 DVDD.t441 697.465
R57 DVDD.n1068 DVDD.t527 697.465
R58 DVDD.n788 DVDD.t353 697.465
R59 DVDD.n765 DVDD.t651 697.465
R60 DVDD.n835 DVDD.t933 697.465
R61 DVDD.n874 DVDD.t56 697.465
R62 DVDD.n880 DVDD.t343 697.465
R63 DVDD.n257 DVDD.t519 694.168
R64 DVDD.n431 DVDD.t923 694.168
R65 DVDD.n449 DVDD.t598 694.168
R66 DVDD.n145 DVDD.t98 694.168
R67 DVDD.n637 DVDD.t92 694.168
R68 DVDD.n548 DVDD.t299 694.168
R69 DVDD.n557 DVDD.t830 694.168
R70 DVDD.n668 DVDD.t899 694.168
R71 DVDD.n20 DVDD.t468 694.168
R72 DVDD.n33 DVDD.t372 694.168
R73 DVDD.n1154 DVDD.t637 694.168
R74 DVDD.n956 DVDD.t917 694.168
R75 DVDD.n917 DVDD.t585 694.168
R76 DVDD.n850 DVDD.t208 694.168
R77 DVDD.t660 DVDD.t666 674.736
R78 DVDD.n181 DVDD.t673 663.062
R79 DVDD.n185 DVDD.t249 663.062
R80 DVDD.n206 DVDD.t235 663.062
R81 DVDD.n314 DVDD.t475 663.062
R82 DVDD.n307 DVDD.t874 663.062
R83 DVDD.n411 DVDD.t685 663.062
R84 DVDD.n418 DVDD.t266 663.062
R85 DVDD.n161 DVDD.t120 663.062
R86 DVDD.n152 DVDD.t557 663.062
R87 DVDD.n463 DVDD.t593 663.062
R88 DVDD.n651 DVDD.t47 663.062
R89 DVDD.n527 DVDD.t725 663.062
R90 DVDD.n76 DVDD.t146 663.062
R91 DVDD.n65 DVDD.t908 663.062
R92 DVDD.n1171 DVDD.t73 663.062
R93 DVDD.n965 DVDD.t894 663.062
R94 DVDD.n1031 DVDD.t244 663.062
R95 DVDD.n951 DVDD.t848 663.062
R96 DVDD.n926 DVDD.t940 663.062
R97 DVDD.n913 DVDD.t506 663.062
R98 DVDD.n802 DVDD.t14 663.062
R99 DVDD.n725 DVDD.t363 663.062
R100 DVDD.n864 DVDD.t601 663.062
R101 DVDD.n885 DVDD.t312 663.062
R102 DVDD.n896 DVDD.t183 663.062
R103 DVDD.n490 DVDD.t710 659.764
R104 DVDD.n496 DVDD.t879 659.764
R105 DVDD.n619 DVDD.t3 659.764
R106 DVDD.n613 DVDD.t153 659.764
R107 DVDD.n587 DVDD.t387 659.764
R108 DVDD.n683 DVDD.t291 659.764
R109 DVDD.n1120 DVDD.t696 659.764
R110 DVDD.n1160 DVDD.t203 659.764
R111 DVDD.n110 DVDD.t491 659.764
R112 DVDD.n1077 DVDD.t578 659.764
R113 DVDD.n762 DVDD.t222 659.764
R114 DVDD.n833 DVDD.n759 629.801
R115 DVDD.n244 DVDD.n180 598.965
R116 DVDD.n238 DVDD.n183 598.965
R117 DVDD.n237 DVDD.n184 598.965
R118 DVDD.n232 DVDD.n187 598.965
R119 DVDD.n212 DVDD.n201 598.965
R120 DVDD.n205 DVDD.n204 598.965
R121 DVDD.n316 DVDD.n262 598.965
R122 DVDD.n272 DVDD.n271 598.965
R123 DVDD.n378 DVDD.n377 598.965
R124 DVDD.n368 DVDD.n367 598.965
R125 DVDD.n347 DVDD.n346 598.965
R126 DVDD.n354 DVDD.n353 598.965
R127 DVDD.n457 DVDD.n456 598.965
R128 DVDD.n150 DVDD.n149 598.965
R129 DVDD.n487 DVDD.n486 598.965
R130 DVDD.n500 DVDD.n499 598.965
R131 DVDD.n623 DVDD.n622 598.965
R132 DVDD.n610 DVDD.n545 598.965
R133 DVDD.n532 DVDD.n531 598.965
R134 DVDD.n654 DVDD.n653 598.965
R135 DVDD.n661 DVDD.n660 598.965
R136 DVDD.n79 DVDD.n78 598.965
R137 DVDD.n27 DVDD.n26 598.965
R138 DVDD.n38 DVDD.n37 598.965
R139 DVDD.n8 DVDD.n7 598.965
R140 DVDD.n1145 DVDD.n104 598.965
R141 DVDD.n972 DVDD.n971 598.965
R142 DVDD.n934 DVDD.n933 598.965
R143 DVDD.n937 DVDD.n936 598.965
R144 DVDD.n1054 DVDD.n1053 598.965
R145 DVDD.n1076 DVDD.n1075 598.965
R146 DVDD.n1084 DVDD.n1083 598.965
R147 DVDD.n1091 DVDD.n1090 598.965
R148 DVDD.n1099 DVDD.n1098 598.965
R149 DVDD.n772 DVDD.n771 598.965
R150 DVDD.n806 DVDD.n805 598.965
R151 DVDD.n819 DVDD.n818 598.965
R152 DVDD.n827 DVDD.n826 598.965
R153 DVDD.n858 DVDD.n857 598.965
R154 DVDD.n723 DVDD.n722 598.965
R155 DVDD.n868 DVDD.n867 598.965
R156 DVDD.n716 DVDD.n715 598.965
R157 DVDD.n899 DVDD.n898 598.965
R158 DVDD.n267 DVDD.n266 595.668
R159 DVDD.n268 DVDD.n265 595.668
R160 DVDD.n374 DVDD.n373 595.668
R161 DVDD.n371 DVDD.n370 595.668
R162 DVDD.n448 DVDD.n154 595.668
R163 DVDD.n468 DVDD.n466 595.668
R164 DVDD.n489 DVDD.n488 595.668
R165 DVDD.n497 DVDD.n140 595.668
R166 DVDD.n620 DVDD.n542 595.668
R167 DVDD.n612 DVDD.n611 595.668
R168 DVDD.n591 DVDD.n589 595.668
R169 DVDD.n582 DVDD.n554 595.668
R170 DVDD.n667 DVDD.n526 595.668
R171 DVDD.n677 DVDD.n676 595.668
R172 DVDD.n689 DVDD.n519 595.668
R173 DVDD.n125 DVDD.n123 595.668
R174 DVDD.n119 DVDD.n118 595.668
R175 DVDD.n70 DVDD.n67 595.668
R176 DVDD.n69 DVDD.n68 595.668
R177 DVDD.n13 DVDD.n12 595.668
R178 DVDD.n1155 DVDD.n100 595.668
R179 DVDD.n1138 DVDD.n113 595.668
R180 DVDD.n1046 DVDD.n928 595.668
R181 DVDD.n980 DVDD.n964 595.668
R182 DVDD.n1013 DVDD.n949 595.668
R183 DVDD.n1004 DVDD.n953 595.668
R184 DVDD.n849 DVDD.n727 595.668
R185 DVDD.n890 DVDD.n887 595.668
R186 DVDD.n889 DVDD.n888 595.668
R187 DVDD.t333 DVDD.t839 570.672
R188 DVDD.t922 DVDD.t538 552.208
R189 DVDD.t325 DVDD.t28 520.318
R190 DVDD.t111 DVDD.t654 495.142
R191 DVDD.t666 DVDD.t32 463.252
R192 DVDD.t570 DVDD.t287 463.252
R193 DVDD.t524 DVDD.t91 458.216
R194 DVDD.n329 DVDD.t518 448.146
R195 DVDD.t932 DVDD.n841 448.146
R196 DVDD.t420 DVDD.t195 401.149
R197 DVDD.t882 DVDD.t570 397.793
R198 DVDD.t43 DVDD.t82 384.365
R199 DVDD.t542 DVDD.t35 384.365
R200 DVDD.n197 DVDD.t968 373.283
R201 DVDD.n386 DVDD.t955 373.283
R202 DVDD.n363 DVDD.t956 373.283
R203 DVDD.n135 DVDD.t946 373.283
R204 DVDD.n18 DVDD.t952 373.283
R205 DVDD.n108 DVDD.t963 373.283
R206 DVDD.n942 DVDD.t970 373.283
R207 DVDD.n783 DVDD.t945 373.283
R208 DVDD.n776 DVDD.t962 373.283
R209 DVDD.n196 DVDD.n194 357.442
R210 DVDD.n385 DVDD.n383 357.442
R211 DVDD.n362 DVDD.n360 357.442
R212 DVDD.n134 DVDD.n132 357.442
R213 DVDD.n17 DVDD.n15 357.442
R214 DVDD.n107 DVDD.n105 357.442
R215 DVDD.n941 DVDD.n939 357.442
R216 DVDD.n782 DVDD.n780 357.442
R217 DVDD.n775 DVDD.n773 357.442
R218 DVDD.n195 DVDD.t959 346.022
R219 DVDD.n384 DVDD.t966 346.022
R220 DVDD.n361 DVDD.t967 346.022
R221 DVDD.n133 DVDD.t965 346.022
R222 DVDD.n16 DVDD.t961 346.022
R223 DVDD.n106 DVDD.t969 346.022
R224 DVDD.n940 DVDD.t960 346.022
R225 DVDD.n781 DVDD.t953 346.022
R226 DVDD.n774 DVDD.t951 346.022
R227 DVDD.n1006 DVDD.t161 336.416
R228 DVDD.t316 DVDD.t133 328.976
R229 DVDD.n958 DVDD.t356 325.618
R230 DVDD.n841 DVDD.t261 325.618
R231 DVDD.n194 DVDD.t774 325.082
R232 DVDD.n383 DVDD.t787 325.082
R233 DVDD.n360 DVDD.t810 325.082
R234 DVDD.n132 DVDD.t764 325.082
R235 DVDD.n15 DVDD.t789 325.082
R236 DVDD.n105 DVDD.t770 325.082
R237 DVDD.n939 DVDD.t812 325.082
R238 DVDD.n780 DVDD.t768 325.082
R239 DVDD.n773 DVDD.t801 325.082
R240 DVDD.n998 DVDD.n997 324.74
R241 DVDD.n1061 DVDD.n923 324.74
R242 DVDD.n1105 DVDD.n910 324.74
R243 DVDD.n962 DVDD.n961 324.74
R244 DVDD.n752 DVDD.n735 324.74
R245 DVDD.t417 DVDD.t107 322.262
R246 DVDD.t277 DVDD.t191 322.262
R247 DVDD.t189 DVDD.t252 322.262
R248 DVDD.t168 DVDD.t753 322.262
R249 DVDD.n1011 DVDD.n950 320.976
R250 DVDD.t720 DVDD.n329 318.906
R251 DVDD.t234 DVDD.t236 315.548
R252 DVDD.t123 DVDD.t119 315.548
R253 DVDD.t724 DVDD.t727 315.548
R254 DVDD.t243 DVDD.t239 315.548
R255 DVDD.t262 DVDD.t882 315.548
R256 DVDD.t751 DVDD.t371 303.8
R257 DVDD.t258 DVDD.t13 303.8
R258 DVDD.t356 DVDD.t916 276.943
R259 DVDD.n739 DVDD.t288 264.455
R260 DVDD.n167 DVDD.t33 264.445
R261 DVDD.n4 DVDD.t29 264.318
R262 DVDD.t889 DVDD.t256 261.837
R263 DVDD.t321 DVDD.t113 261.837
R264 DVDD.t331 DVDD.t292 258.481
R265 DVDD.t402 DVDD.t204 258.481
R266 DVDD.n168 DVDD.t667 255.905
R267 DVDD.n786 DVDD.t112 255.905
R268 DVDD.n804 DVDD.t860 255.905
R269 DVDD.n192 DVDD.t44 255.904
R270 DVDD.n163 DVDD.t760 255.904
R271 DVDD.n555 DVDD.t75 255.904
R272 DVDD.n44 DVDD.t1 255.904
R273 DVDD.n967 DVDD.t175 255.904
R274 DVDD.n740 DVDD.t571 255.904
R275 DVDD.n906 DVDD.t758 255.904
R276 DVDD.n561 DVDD.t110 255.073
R277 DVDD.n772 DVDD.t259 254.02
R278 DVDD.n129 DVDD.t188 252.732
R279 DVDD.n280 DVDD.t543 250.724
R280 DVDD.n564 DVDD.t421 250.724
R281 DVDD.n705 DVDD.t913 250.722
R282 DVDD.n285 DVDD.t108 249.363
R283 DVDD.n224 DVDD.t83 249.363
R284 DVDD.n290 DVDD.t36 249.363
R285 DVDD.n392 DVDD.t278 249.363
R286 DVDD.n397 DVDD.t334 249.363
R287 DVDD.n405 DVDD.t493 249.363
R288 DVDD.n517 DVDD.t416 249.363
R289 DVDD.n699 DVDD.t253 249.363
R290 DVDD.n704 DVDD.t754 249.363
R291 DVDD.n127 DVDD.t617 249.363
R292 DVDD.n51 DVDD.t230 249.363
R293 DVDD.n1128 DVDD.t167 249.363
R294 DVDD.n249 DVDD.t280 249.362
R295 DVDD.n301 DVDD.t228 249.362
R296 DVDD.n397 DVDD.t856 249.362
R297 DVDD.n631 DVDD.t226 249.362
R298 DVDD.n699 DVDD.t716 249.362
R299 DVDD.n921 DVDD.t134 249.362
R300 DVDD.n1070 DVDD.t756 249.362
R301 DVDD.n283 DVDD.t171 247.394
R302 DVDD.n281 DVDD.t418 247.394
R303 DVDD.n226 DVDD.t397 247.394
R304 DVDD.n321 DVDD.t719 247.394
R305 DVDD.n157 DVDD.t106 247.394
R306 DVDD.n393 DVDD.t717 247.394
R307 DVDD.n643 DVDD.t500 247.394
R308 DVDD.n562 DVDD.t196 247.394
R309 DVDD.n691 DVDD.t194 247.394
R310 DVDD.n703 DVDD.t169 247.394
R311 DVDD.n1113 DVDD.t481 247.394
R312 DVDD.n58 DVDD.t395 247.394
R313 DVDD.n53 DVDD.t752 247.394
R314 DVDD.n393 DVDD.t192 247.394
R315 DVDD.n425 DVDD.t104 247.394
R316 DVDD.n474 DVDD.t515 247.394
R317 DVDD.n635 DVDD.t525 247.394
R318 DVDD.n598 DVDD.t393 247.394
R319 DVDD.n703 DVDD.t419 247.394
R320 DVDD.n52 DVDD.t405 247.394
R321 DVDD.n1069 DVDD.t282 247.394
R322 DVDD.n1074 DVDD.t255 247.394
R323 DVDD.n258 DVDD.t453 245.178
R324 DVDD.n636 DVDD.t368 245.178
R325 DVDD.n522 DVDD.t318 245.178
R326 DVDD.n520 DVDD.t502 245.178
R327 DVDD.n126 DVDD.t366 245.178
R328 DVDD.n1122 DVDD.t689 245.178
R329 DVDD.n32 DVDD.t200 245.178
R330 DVDD.n97 DVDD.t136 245.178
R331 DVDD.n947 DVDD.t800 245.178
R332 DVDD.n277 DVDD.t257 245.178
R333 DVDD.n430 DVDD.t198 245.178
R334 DVDD.n467 DVDD.t855 245.178
R335 DVDD.n590 DVDD.t399 245.178
R336 DVDD.n552 DVDD.t504 245.178
R337 DVDD.n559 DVDD.t615 245.178
R338 DVDD.n35 DVDD.t114 245.178
R339 DVDD.n112 DVDD.t563 245.178
R340 DVDD.t30 DVDD.t893 245.054
R341 DVDD.n514 DVDD.t567 243.886
R342 DVDD.n381 DVDD.t523 243.508
R343 DVDD.n684 DVDD.t332 243.508
R344 DVDD.n698 DVDD.t190 243.508
R345 DVDD.n124 DVDD.t401 243.508
R346 DVDD.n1123 DVDD.t569 243.508
R347 DVDD.n98 DVDD.t403 243.508
R348 DVDD.n252 DVDD.t721 243.508
R349 DVDD.n275 DVDD.t881 243.508
R350 DVDD.n278 DVDD.t173 243.508
R351 DVDD.n592 DVDD.t750 243.508
R352 DVDD.n573 DVDD.t565 243.508
R353 DVDD.n114 DVDD.t513 243.508
R354 DVDD.t80 DVDD.t97 243.375
R355 DVDD.t831 DVDD.t298 243.375
R356 DVDD.t674 DVDD.t467 243.375
R357 DVDD.t939 DVDD.t305 238.339
R358 DVDD.t505 DVDD.t863 238.339
R359 DVDD.n821 DVDD.n764 235.248
R360 DVDD.n959 DVDD.n958 231.138
R361 DVDD.n734 DVDD.t798 231.017
R362 DVDD.t614 DVDD.t420 229.947
R363 DVDD.n331 DVDD.n330 226.786
R364 DVDD.n440 DVDD.n439 226.786
R365 DVDD.n442 DVDD.n441 226.786
R366 DVDD.n581 DVDD.n580 226.786
R367 DVDD.n645 DVDD.n534 226.786
R368 DVDD.n1169 DVDD.n1168 226.786
R369 DVDD.n1167 DVDD.n1166 226.786
R370 DVDD.n1045 DVDD.n929 226.786
R371 DVDD.n843 DVDD.n842 226.786
R372 DVDD.t490 DVDD.t562 224.912
R373 DVDD.n754 DVDD.n734 223.451
R374 DVDD.n1168 DVDD.t72 221.555
R375 DVDD.n194 DVDD.t954 215.829
R376 DVDD.n383 DVDD.t948 215.829
R377 DVDD.n360 DVDD.t950 215.829
R378 DVDD.n132 DVDD.t947 215.829
R379 DVDD.n15 DVDD.t944 215.829
R380 DVDD.n105 DVDD.t957 215.829
R381 DVDD.n939 DVDD.t964 215.829
R382 DVDD.n780 DVDD.t958 215.829
R383 DVDD.n773 DVDD.t971 215.829
R384 DVDD.t577 DVDD.t584 206.45
R385 DVDD.t377 DVDD.t478 198.058
R386 DVDD.t348 DVDD.t605 198.058
R387 DVDD.n195 DVDD.t761 193.337
R388 DVDD.n384 DVDD.t814 193.337
R389 DVDD.n361 DVDD.t781 193.337
R390 DVDD.n133 DVDD.t791 193.337
R391 DVDD.n16 DVDD.t819 193.337
R392 DVDD.n106 DVDD.t805 193.337
R393 DVDD.n940 DVDD.t822 193.337
R394 DVDD.n781 DVDD.t778 193.337
R395 DVDD.n774 DVDD.t784 193.337
R396 DVDD.t662 DVDD.t43 186.308
R397 DVDD.t632 DVDD.t422 182.952
R398 DVDD.n197 DVDD.t808 167.63
R399 DVDD.n386 DVDD.t772 167.63
R400 DVDD.n363 DVDD.t803 167.63
R401 DVDD.n135 DVDD.t766 167.63
R402 DVDD.n18 DVDD.t776 167.63
R403 DVDD.n108 DVDD.t817 167.63
R404 DVDD.n942 DVDD.t796 167.63
R405 DVDD.n783 DVDD.t794 167.63
R406 DVDD.n776 DVDD.t825 167.63
R407 DVDD.t231 DVDD.t660 161.131
R408 DVDD.t34 DVDD.t804 161.131
R409 DVDD.t809 DVDD.t471 161.131
R410 DVDD.t613 DVDD.t274 161.131
R411 DVDD.t703 DVDD.t451 161.131
R412 DVDD.t118 DVDD.t534 161.131
R413 DVDD.t122 DVDD.t576 161.131
R414 DVDD.t391 DVDD.t773 161.131
R415 DVDD.t97 DVDD.t715 161.131
R416 DVDD.t388 DVDD.t829 161.131
R417 DVDD.t67 DVDD.t442 161.131
R418 DVDD.t298 DVDD.t151 161.131
R419 DVDD.t76 DVDD.t444 161.131
R420 DVDD.t127 DVDD.t722 161.131
R421 DVDD.t70 DVDD.t325 161.131
R422 DVDD.t26 DVDD.t693 161.131
R423 DVDD.t797 DVDD.t144 161.131
R424 DVDD.t494 DVDD.t9 161.131
R425 DVDD.t467 DVDD.t206 161.131
R426 DVDD.t164 DVDD.t498 161.131
R427 DVDD.t777 DVDD.t511 161.131
R428 DVDD.t892 DVDD.t868 161.131
R429 DVDD.t440 DVDD.t238 161.131
R430 DVDD.t40 DVDD.t360 161.131
R431 DVDD.t462 DVDD.t241 161.131
R432 DVDD.t260 DVDD.t826 161.131
R433 DVDD.t359 DVDD.t352 161.131
R434 DVDD.t818 DVDD.t428 161.131
R435 DVDD.t338 DVDD.t276 161.131
R436 DVDD.n734 DVDD.t949 158.716
R437 DVDD.t396 DVDD.t247 156.095
R438 DVDD.t554 DVDD.t105 156.095
R439 DVDD.t281 DVDD.t583 156.095
R440 DVDD.n196 DVDD.n195 152
R441 DVDD.n198 DVDD.n197 152
R442 DVDD.n385 DVDD.n384 152
R443 DVDD.n387 DVDD.n386 152
R444 DVDD.n362 DVDD.n361 152
R445 DVDD.n364 DVDD.n363 152
R446 DVDD.n134 DVDD.n133 152
R447 DVDD.n136 DVDD.n135 152
R448 DVDD.n17 DVDD.n16 152
R449 DVDD.n19 DVDD.n18 152
R450 DVDD.n107 DVDD.n106 152
R451 DVDD.n109 DVDD.n108 152
R452 DVDD.n941 DVDD.n940 152
R453 DVDD.n943 DVDD.n942 152
R454 DVDD.n782 DVDD.n781 152
R455 DVDD.n784 DVDD.n783 152
R456 DVDD.n775 DVDD.n774 152
R457 DVDD.n777 DVDD.n776 152
R458 DVDD.t233 DVDD.t662 151.06
R459 DVDD.t473 DVDD.t406 151.06
R460 DVDD.t538 DVDD.t121 151.06
R461 DVDD.t924 DVDD.t264 151.06
R462 DVDD.t594 DVDD.t80 151.06
R463 DVDD.t186 DVDD.t61 151.06
R464 DVDD.t385 DVDD.t831 151.06
R465 DVDD.t5 DVDD.t630 151.06
R466 DVDD.t71 DVDD.t321 151.06
R467 DVDD.t911 DVDD.t375 151.06
R468 DVDD.t143 DVDD.t674 151.06
R469 DVDD.t694 DVDD.t729 151.06
R470 DVDD.t870 DVDD.t895 151.06
R471 DVDD.t852 DVDD.t914 151.06
R472 DVDD.t654 DVDD.t15 151.06
R473 DVDD.t308 DVDD.t51 151.06
R474 DVDD.t232 DVDD.t550 149.382
R475 DVDD.t274 DVDD.t516 149.382
R476 DVDD.t536 DVDD.t891 149.382
R477 DVDD.t928 DVDD.t122 149.382
R478 DVDD.t572 DVDD.t383 149.382
R479 DVDD.t829 DVDD.t564 149.382
R480 DVDD.t833 DVDD.t67 149.382
R481 DVDD.t140 DVDD.t904 149.382
R482 DVDD.t319 DVDD.t26 149.382
R483 DVDD.t144 DVDD.t373 149.382
R484 DVDD.t579 DVDD.t638 149.382
R485 DVDD.t866 DVDD.t284 149.382
R486 DVDD.t360 DVDD.t434 149.382
R487 DVDD.t241 DVDD.t648 149.382
R488 DVDD.t936 DVDD.t458 149.382
R489 DVDD.t652 DVDD.t260 149.382
R490 DVDD.t726 DVDD.t354 149.382
R491 DVDD.t428 DVDD.t57 149.382
R492 DVDD.t664 DVDD.t782 140.989
R493 DVDD.t782 DVDD.t234 140.989
R494 DVDD.t236 DVDD.t658 140.989
R495 DVDD.t658 DVDD.t811 140.989
R496 DVDD.t811 DVDD.t233 140.989
R497 DVDD.t775 DVDD.t250 140.989
R498 DVDD.t546 DVDD.t447 140.989
R499 DVDD.t447 DVDD.t671 140.989
R500 DVDD.t452 DVDD.t718 140.989
R501 DVDD.t876 DVDD.t883 140.989
R502 DVDD.t883 DVDD.t700 140.989
R503 DVDD.t256 DVDD.t172 140.989
R504 DVDD.t35 DVDD.t417 140.989
R505 DVDD.t107 DVDD.t170 140.989
R506 DVDD.t845 DVDD.t536 140.989
R507 DVDD.t119 DVDD.t845 140.989
R508 DVDD.t540 DVDD.t123 140.989
R509 DVDD.t843 DVDD.t540 140.989
R510 DVDD.t103 DVDD.t197 140.989
R511 DVDD.t835 DVDD.t686 140.989
R512 DVDD.t788 DVDD.t835 140.989
R513 DVDD.t191 DVDD.t333 140.989
R514 DVDD.t383 DVDD.t22 140.989
R515 DVDD.t478 DVDD.t16 140.989
R516 DVDD.t99 DVDD.t609 140.989
R517 DVDD.t65 DVDD.t792 140.989
R518 DVDD.t792 DVDD.t878 140.989
R519 DVDD.t711 DVDD.t101 140.989
R520 DVDD.t101 DVDD.t86 140.989
R521 DVDD.t765 DVDD.t186 140.989
R522 DVDD.t195 DVDD.t109 140.989
R523 DVDD.t564 DVDD.t614 140.989
R524 DVDD.t445 DVDD.t386 140.989
R525 DVDD.t503 DVDD.t749 140.989
R526 DVDD.t389 DVDD.t827 140.989
R527 DVDD.t302 DVDD.t18 140.989
R528 DVDD.t628 DVDD.t138 140.989
R529 DVDD.t138 DVDD.t2 140.989
R530 DVDD.t154 DVDD.t296 140.989
R531 DVDD.t296 DVDD.t21 140.989
R532 DVDD.t141 DVDD.t5 140.989
R533 DVDD.t225 DVDD.t524 140.989
R534 DVDD.t367 DVDD.t499 140.989
R535 DVDD.t93 DVDD.t78 140.989
R536 DVDD.t78 DVDD.t46 140.989
R537 DVDD.t727 DVDD.t125 140.989
R538 DVDD.t904 DVDD.t747 140.989
R539 DVDD.t746 DVDD.t294 140.989
R540 DVDD.t252 DVDD.t168 140.989
R541 DVDD.t691 DVDD.t319 140.989
R542 DVDD.t72 DVDD.t691 140.989
R543 DVDD.t68 DVDD.t323 140.989
R544 DVDD.t323 DVDD.t690 140.989
R545 DVDD.t113 DVDD.t404 140.989
R546 DVDD.t229 DVDD.t751 140.989
R547 DVDD.t199 DVDD.t394 140.989
R548 DVDD.t147 DVDD.t680 140.989
R549 DVDD.t680 DVDD.t497 140.989
R550 DVDD.t497 DVDD.t143 140.989
R551 DVDD.t469 DVDD.t162 140.989
R552 DVDD.t204 DVDD.t465 140.989
R553 DVDD.t638 DVDD.t329 140.989
R554 DVDD.t329 DVDD.t490 140.989
R555 DVDD.t634 DVDD.t327 140.989
R556 DVDD.t327 DVDD.t489 140.989
R557 DVDD.t820 DVDD.t695 140.989
R558 DVDD.t688 DVDD.t400 140.989
R559 DVDD.t697 DVDD.t735 140.989
R560 DVDD.t616 DVDD.t187 140.989
R561 DVDD.t409 DVDD.t866 140.989
R562 DVDD.t918 DVDD.t157 140.989
R563 DVDD.t116 DVDD.t413 140.989
R564 DVDD.t920 DVDD.t156 140.989
R565 DVDD.t156 DVDD.t852 140.989
R566 DVDD.t434 DVDD.t620 140.989
R567 DVDD.t620 DVDD.t243 140.989
R568 DVDD.t239 DVDD.t438 140.989
R569 DVDD.t438 DVDD.t85 140.989
R570 DVDD.t460 DVDD.t939 140.989
R571 DVDD.t941 DVDD.t644 140.989
R572 DVDD.t528 DVDD.t611 140.989
R573 DVDD.t611 DVDD.t577 140.989
R574 DVDD.t38 DVDD.t505 140.989
R575 DVDD.t507 DVDD.t588 140.989
R576 DVDD.t857 DVDD.t262 140.989
R577 DVDD.t861 DVDD.t857 140.989
R578 DVDD.t261 DVDD.t861 140.989
R579 DVDD.t285 DVDD.t936 140.989
R580 DVDD.t934 DVDD.t223 140.989
R581 DVDD.t283 DVDD.t934 140.989
R582 DVDD.t13 DVDD.t785 140.989
R583 DVDD.t656 DVDD.t10 140.989
R584 DVDD.t802 DVDD.t656 140.989
R585 DVDD.t15 DVDD.t802 140.989
R586 DVDD.t354 DVDD.t779 140.989
R587 DVDD.t605 DVDD.t211 140.989
R588 DVDD.t211 DVDD.t454 140.989
R589 DVDD.t454 DVDD.t608 140.989
R590 DVDD.t184 DVDD.t346 140.989
R591 DVDD.t346 DVDD.t337 140.989
R592 DVDD.t337 DVDD.t181 140.989
R593 DVDD.t221 DVDD.t149 137.633
R594 DVDD.t82 DVDD.t737 135.954
R595 DVDD.t381 DVDD.t277 135.954
R596 DVDD.t270 DVDD.t552 135.954
R597 DVDD.t133 DVDD.t526 135.954
R598 DVDD.t457 DVDD.t357 135.954
R599 DVDD.t550 DVDD.t245 134.276
R600 DVDD.t448 DVDD.t743 134.276
R601 DVDD.t672 DVDD.t775 134.276
R602 DVDD.t63 DVDD.t251 134.276
R603 DVDD.t626 DVDD.t4 134.276
R604 DVDD.t607 DVDD.t918 130.919
R605 DVDD.t548 DVDD.t739 129.24
R606 DVDD.t450 DVDD.t248 129.24
R607 DVDD.t451 DVDD.t476 129.24
R608 DVDD.t267 DVDD.t391 129.24
R609 DVDD.t9 DVDD.t909 129.24
R610 DVDD.t276 DVDD.t306 129.24
R611 DVDD.t0 DVDD.t71 125.883
R612 DVDD.t759 DVDD.t844 124.206
R613 DVDD.t59 DVDD.t95 124.206
R614 DVDD.t624 DVDD.t300 124.206
R615 DVDD.t174 DVDD.t412 124.206
R616 DVDD.t254 DVDD.t528 124.206
R617 DVDD.n764 DVDD.t423 123.507
R618 DVDD.t713 DVDD.t709 122.526
R619 DVDD.t853 DVDD.t152 122.526
R620 DVDD.t430 DVDD.t89 122.526
R621 DVDD.t603 DVDD.t851 122.526
R622 DVDD.t213 DVDD.t602 122.526
R623 DVDD.t859 DVDD.t652 122.526
R624 DVDD.t757 DVDD.t340 122.526
R625 DVDD.t804 DVDD.t231 120.849
R626 DVDD.t247 DVDD.t809 120.849
R627 DVDD.t472 DVDD.t613 120.849
R628 DVDD.t887 DVDD.t520 120.849
R629 DVDD.t701 DVDD.t485 120.849
R630 DVDD.t873 DVDD.t473 120.849
R631 DVDD.t844 DVDD.t118 120.849
R632 DVDD.t576 DVDD.t269 120.849
R633 DVDD.t926 DVDD.t841 120.849
R634 DVDD.t573 DVDD.t815 120.849
R635 DVDD.t264 DVDD.t684 120.849
R636 DVDD.t24 DVDD.t554 120.849
R637 DVDD.t364 DVDD.t270 120.849
R638 DVDD.t715 DVDD.t37 120.849
R639 DVDD.t115 DVDD.t767 120.849
R640 DVDD.t151 DVDD.t20 120.849
R641 DVDD.t8 DVDD.t137 120.849
R642 DVDD.t50 DVDD.t76 120.849
R643 DVDD.t693 DVDD.t70 120.849
R644 DVDD.t906 DVDD.t797 120.849
R645 DVDD.t678 DVDD.t369 120.849
R646 DVDD.t495 DVDD.t813 120.849
R647 DVDD.t145 DVDD.t911 120.849
R648 DVDD.t206 DVDD.t164 120.849
R649 DVDD.t699 DVDD.t777 120.849
R650 DVDD.t412 DVDD.t892 120.849
R651 DVDD.t238 DVDD.t40 120.849
R652 DVDD.t583 DVDD.t484 120.849
R653 DVDD.t795 DVDD.t359 120.849
R654 DVDD.t599 DVDD.t457 120.849
R655 DVDD.t309 DVDD.t818 120.849
R656 DVDD.t344 DVDD.t53 120.849
R657 DVDD.t335 DVDD.t771 120.849
R658 DVDD.t182 DVDD.t308 120.849
R659 DVDD.n441 DVDD.t572 119.171
R660 DVDD.n842 DVDD.t726 119.171
R661 DVDD.t592 DVDD.t377 117.492
R662 DVDD.t600 DVDD.t348 117.492
R663 DVDD.t885 DVDD.t482 115.814
R664 DVDD.t574 DVDD.t837 115.814
R665 DVDD.t411 DVDD.t379 115.814
R666 DVDD.t676 DVDD.t823 115.814
R667 DVDD.t755 DVDD.t310 115.814
R668 DVDD.t339 DVDD.t350 115.814
R669 DVDD.t342 DVDD.t806 115.814
R670 DVDD.n330 DVDD.t664 114.135
R671 DVDD.t618 DVDD.t714 114.135
R672 DVDD.t6 DVDD.t150 114.135
R673 DVDD.n534 DVDD.t93 114.135
R674 DVDD.n1167 DVDD.t469 114.135
R675 DVDD.n329 DVDD.n328 113.394
R676 DVDD.n841 DVDD.n840 113.394
R677 DVDD.t669 DVDD.t741 110.778
R678 DVDD.t166 DVDD.t733 110.778
R679 DVDD.t568 DVDD.t820 110.778
R680 DVDD.t668 DVDD.t762 109.1
R681 DVDD.t584 DVDD.t580 109.1
R682 DVDD.t622 DVDD.t623 109.1
R683 DVDD.t595 DVDD.t25 107.421
R684 DVDD.t272 DVDD.t555 107.421
R685 DVDD.t630 DVDD.t225 107.421
R686 DVDD.t729 DVDD.t616 107.421
R687 DVDD.t215 DVDD.t769 107.421
R688 DVDD.t455 DVDD.t361 107.421
R689 DVDD.t671 DVDD.t279 104.064
R690 DVDD.t749 DVDD.t389 104.064
R691 DVDD.t432 DVDD.t87 104.064
R692 DVDD.t294 DVDD.t415 104.064
R693 DVDD.t400 DVDD.t697 104.064
R694 DVDD.n958 DVDD.t870 104.064
R695 DVDD.t597 DVDD.t556 102.385
R696 DVDD.t722 DVDD.t48 102.385
R697 DVDD.t315 DVDD.t77 102.385
R698 DVDD.t209 DVDD.t159 102.385
R699 DVDD.t207 DVDD.t362 102.385
R700 DVDD.n580 DVDD.t445 100.707
R701 DVDD.n929 DVDD.t460 100.707
R702 DVDD.n433 DVDD.n364 99.8577
R703 DVDD.n795 DVDD.n777 98.4469
R704 DVDD.t644 DVDD.t313 97.3503
R705 DVDD.t459 DVDD.t560 97.3503
R706 DVDD.t938 DVDD.t558 97.3503
R707 DVDD.t588 DVDD.t426 97.3503
R708 DVDD.t84 DVDD.t704 97.3503
R709 DVDD.t509 DVDD.t706 97.3503
R710 DVDD.t223 DVDD.t632 97.3503
R711 DVDD.t875 DVDD.t474 95.6719
R712 DVDD.t265 DVDD.t683 95.6719
R713 DVDD.t142 DVDD.t907 95.6719
R714 DVDD.t640 DVDD.t699 95.6719
R715 DVDD.t424 DVDD.t932 95.6719
R716 DVDD.t41 DVDD.t220 95.6719
R717 DVDD.t275 DVDD.t289 95.6719
R718 DVDD.t217 DVDD.t309 95.6719
R719 DVDD.t180 DVDD.t311 95.6719
R720 DVDD.t544 DVDD.t720 93.9934
R721 DVDD.t129 DVDD.t45 93.9934
R722 DVDD.t900 DVDD.t189 93.9934
R723 DVDD.n1168 DVDD.t68 93.9934
R724 DVDD.t172 DVDD.t542 92.315
R725 DVDD.t745 DVDD.t131 92.315
R726 DVDD.t328 DVDD.t463 92.315
R727 DVDD.t242 DVDD.t943 92.315
R728 DVDD.t12 DVDD.t219 92.315
R729 DVDD.t700 DVDD.t227 90.6365
R730 DVDD.t872 DVDD.t880 90.6365
R731 DVDD.t492 DVDD.t788 90.6365
R732 DVDD.t522 DVDD.t682 90.6365
R733 DVDD.t74 DVDD.t388 90.6365
R734 DVDD.t562 DVDD.t487 90.6365
R735 DVDD.t512 DVDD.t634 90.6365
R736 DVDD.t847 DVDD.t116 90.6365
R737 DVDD.t586 DVDD.t530 90.6365
R738 DVDD.t914 DVDD.t440 88.9581
R739 DVDD.t510 DVDD.t532 88.9581
R740 DVDD.t708 DVDD.t582 88.9581
R741 DVDD.n199 DVDD.n198 88.1705
R742 DVDD.n440 DVDD.t843 87.2797
R743 DVDD.t642 DVDD.t316 87.2797
R744 DVDD.t590 DVDD.t429 87.2797
R745 DVDD.n759 DVDD.t42 86.7743
R746 DVDD.n198 DVDD.n196 86.1712
R747 DVDD.n387 DVDD.n385 86.1712
R748 DVDD.n364 DVDD.n362 86.1712
R749 DVDD.n136 DVDD.n134 86.1712
R750 DVDD.n19 DVDD.n17 86.1712
R751 DVDD.n109 DVDD.n107 86.1712
R752 DVDD.n943 DVDD.n941 86.1712
R753 DVDD.n784 DVDD.n782 86.1712
R754 DVDD.n777 DVDD.n775 86.1712
R755 DVDD.t489 DVDD.t731 85.6012
R756 DVDD.t608 DVDD.t55 85.6012
R757 DVDD.t317 DVDD.t290 83.9228
R758 DVDD.t135 DVDD.t202 83.9228
R759 DVDD.t413 DVDD.t849 83.9228
R760 DVDD.t799 DVDD.t920 83.9228
R761 DVDD.t898 DVDD.t431 82.2443
R762 DVDD.t636 DVDD.t165 82.2443
R763 DVDD.n1144 DVDD.n109 79.4853
R764 DVDD.t431 DVDD.t295 78.8874
R765 DVDD.t753 DVDD.t912 78.8874
R766 DVDD.t165 DVDD.t486 78.8874
R767 DVDD.n92 DVDD.n19 77.8603
R768 DVDD.t16 DVDD.t854 77.209
R769 DVDD.t271 DVDD.t514 77.209
R770 DVDD.t827 DVDD.t398 77.209
R771 DVDD.t443 DVDD.t392 77.209
R772 DVDD.t501 DVDD.t902 77.209
R773 DVDD.t193 DVDD.t746 77.209
R774 DVDD.t735 DVDD.t365 77.209
R775 DVDD.t790 DVDD.t480 77.209
R776 DVDD.t305 DVDD.t941 77.209
R777 DVDD.t863 DVDD.t507 77.209
R778 DVDD.n1024 DVDD.n943 75.6653
R779 DVDD.n785 DVDD.n784 75.6409
R780 DVDD.n399 DVDD.n387 73.6767
R781 DVDD.t85 DVDD.t646 72.1736
R782 DVDD.t650 DVDD.t283 72.1736
R783 DVDD.t386 DVDD.t503 70.4952
R784 DVDD.t695 DVDD.t688 70.4952
R785 DVDD.t304 DVDD.t409 70.4952
R786 DVDD.t893 DVDD.t304 70.4952
R787 DVDD.t896 DVDD.t30 70.4952
R788 DVDD.t178 DVDD.t896 70.4952
R789 DVDD.t864 DVDD.t178 70.4952
R790 DVDD.t176 DVDD.t864 70.4952
R791 DVDD.t408 DVDD.t176 70.4952
R792 DVDD.t27 DVDD.t408 70.4952
R793 DVDD.t895 DVDD.t27 70.4952
R794 DVDD.t157 DVDD.t160 70.4952
R795 DVDD.t160 DVDD.t847 70.4952
R796 DVDD.t131 DVDD.t140 68.8168
R797 DVDD.t463 DVDD.t579 68.8168
R798 DVDD.t646 DVDD.t242 68.8168
R799 DVDD.t219 DVDD.t650 68.8168
R800 DVDD.n759 DVDD.t425 68.0124
R801 DVDD.t731 DVDD.t640 65.4599
R802 DVDD.t220 DVDD.t424 65.4599
R803 DVDD.t458 DVDD.t275 65.4599
R804 DVDD.t55 DVDD.t217 65.4599
R805 DVDD.t854 DVDD.t271 63.7814
R806 DVDD.t514 DVDD.t594 63.7814
R807 DVDD.t398 DVDD.t443 63.7814
R808 DVDD.t392 DVDD.t385 63.7814
R809 DVDD.t292 DVDD.t501 63.7814
R810 DVDD.t902 DVDD.t193 63.7814
R811 DVDD.t365 DVDD.t790 63.7814
R812 DVDD.t480 DVDD.t694 63.7814
R813 DVDD.n180 DVDD.t670 63.3219
R814 DVDD.n180 DVDD.t547 63.3219
R815 DVDD.n183 DVDD.t246 63.3219
R816 DVDD.n183 DVDD.t744 63.3219
R817 DVDD.n184 DVDD.t551 63.3219
R818 DVDD.n184 DVDD.t449 63.3219
R819 DVDD.n187 DVDD.t740 63.3219
R820 DVDD.n187 DVDD.t763 63.3219
R821 DVDD.n201 DVDD.t237 63.3219
R822 DVDD.n201 DVDD.t659 63.3219
R823 DVDD.n204 DVDD.t665 63.3219
R824 DVDD.n204 DVDD.t783 63.3219
R825 DVDD.n262 DVDD.t517 63.3219
R826 DVDD.n262 DVDD.t483 63.3219
R827 DVDD.n266 DVDD.t477 63.3219
R828 DVDD.n266 DVDD.t521 63.3219
R829 DVDD.n265 DVDD.t888 63.3219
R830 DVDD.n265 DVDD.t702 63.3219
R831 DVDD.n271 DVDD.t877 63.3219
R832 DVDD.n271 DVDD.t884 63.3219
R833 DVDD.n377 DVDD.t687 63.3219
R834 DVDD.n377 DVDD.t836 63.3219
R835 DVDD.n373 DVDD.t842 63.3219
R836 DVDD.n373 DVDD.t816 63.3219
R837 DVDD.n370 DVDD.t268 63.3219
R838 DVDD.n370 DVDD.t927 63.3219
R839 DVDD.n367 DVDD.t929 63.3219
R840 DVDD.n367 DVDD.t575 63.3219
R841 DVDD.n346 DVDD.t537 63.3219
R842 DVDD.n346 DVDD.t846 63.3219
R843 DVDD.n353 DVDD.t124 63.3219
R844 DVDD.n353 DVDD.t541 63.3219
R845 DVDD.n154 DVDD.t384 63.3219
R846 DVDD.n154 DVDD.t23 63.3219
R847 DVDD.n456 DVDD.t553 63.3219
R848 DVDD.n456 DVDD.t380 63.3219
R849 DVDD.n149 DVDD.t596 63.3219
R850 DVDD.n149 DVDD.t273 63.3219
R851 DVDD.n466 DVDD.t479 63.3219
R852 DVDD.n466 DVDD.t17 63.3219
R853 DVDD.n486 DVDD.t100 63.3219
R854 DVDD.n486 DVDD.t610 63.3219
R855 DVDD.n488 DVDD.t66 63.3219
R856 DVDD.n488 DVDD.t793 63.3219
R857 DVDD.n140 DVDD.t712 63.3219
R858 DVDD.n140 DVDD.t102 63.3219
R859 DVDD.n499 DVDD.t619 63.3219
R860 DVDD.n499 DVDD.t60 63.3219
R861 DVDD.n622 DVDD.t7 63.3219
R862 DVDD.n622 DVDD.t625 63.3219
R863 DVDD.n542 DVDD.t155 63.3219
R864 DVDD.n542 DVDD.t297 63.3219
R865 DVDD.n611 DVDD.t629 63.3219
R866 DVDD.n611 DVDD.t139 63.3219
R867 DVDD.n545 DVDD.t303 63.3219
R868 DVDD.n545 DVDD.t19 63.3219
R869 DVDD.n589 DVDD.t390 63.3219
R870 DVDD.n589 DVDD.t828 63.3219
R871 DVDD.n554 DVDD.t834 63.3219
R872 DVDD.n554 DVDD.t446 63.3219
R873 DVDD.n531 DVDD.t94 63.3219
R874 DVDD.n531 DVDD.t79 63.3219
R875 DVDD.n653 DVDD.t49 63.3219
R876 DVDD.n653 DVDD.t90 63.3219
R877 DVDD.n660 DVDD.t130 63.3219
R878 DVDD.n660 DVDD.t433 63.3219
R879 DVDD.n526 DVDD.t728 63.3219
R880 DVDD.n526 DVDD.t126 63.3219
R881 DVDD.n676 DVDD.t905 63.3219
R882 DVDD.n676 DVDD.t748 63.3219
R883 DVDD.n519 DVDD.t293 63.3219
R884 DVDD.n519 DVDD.t903 63.3219
R885 DVDD.n123 DVDD.t698 63.3219
R886 DVDD.n123 DVDD.t736 63.3219
R887 DVDD.n118 DVDD.t734 63.3219
R888 DVDD.n118 DVDD.t821 63.3219
R889 DVDD.n78 DVDD.t148 63.3219
R890 DVDD.n78 DVDD.t681 63.3219
R891 DVDD.n67 DVDD.t910 63.3219
R892 DVDD.n67 DVDD.t370 63.3219
R893 DVDD.n68 DVDD.t679 63.3219
R894 DVDD.n68 DVDD.t496 63.3219
R895 DVDD.n26 DVDD.t374 63.3219
R896 DVDD.n26 DVDD.t824 63.3219
R897 DVDD.n37 DVDD.t69 63.3219
R898 DVDD.n37 DVDD.t324 63.3219
R899 DVDD.n7 DVDD.t320 63.3219
R900 DVDD.n7 DVDD.t692 63.3219
R901 DVDD.n12 DVDD.t470 63.3219
R902 DVDD.n12 DVDD.t163 63.3219
R903 DVDD.n100 DVDD.t205 63.3219
R904 DVDD.n100 DVDD.t466 63.3219
R905 DVDD.n104 DVDD.t639 63.3219
R906 DVDD.n104 DVDD.t330 63.3219
R907 DVDD.n113 DVDD.t488 63.3219
R908 DVDD.n113 DVDD.t635 63.3219
R909 DVDD.n928 DVDD.t649 63.3219
R910 DVDD.n928 DVDD.t461 63.3219
R911 DVDD.n971 DVDD.t867 63.3219
R912 DVDD.n971 DVDD.t410 63.3219
R913 DVDD.n964 DVDD.t897 63.3219
R914 DVDD.n964 DVDD.t865 63.3219
R915 DVDD.n933 DVDD.t240 63.3219
R916 DVDD.n933 DVDD.t439 63.3219
R917 DVDD.n936 DVDD.t435 63.3219
R918 DVDD.n936 DVDD.t621 63.3219
R919 DVDD.n949 DVDD.t850 63.3219
R920 DVDD.n949 DVDD.t921 63.3219
R921 DVDD.n953 DVDD.t919 63.3219
R922 DVDD.n953 DVDD.t158 63.3219
R923 DVDD.n1053 DVDD.t942 63.3219
R924 DVDD.n1053 DVDD.t645 63.3219
R925 DVDD.n1075 DVDD.t529 63.3219
R926 DVDD.n1075 DVDD.t612 63.3219
R927 DVDD.n1083 DVDD.t581 63.3219
R928 DVDD.n1083 DVDD.t533 63.3219
R929 DVDD.n1090 DVDD.t587 63.3219
R930 DVDD.n1090 DVDD.t39 63.3219
R931 DVDD.n1098 DVDD.t508 63.3219
R932 DVDD.n1098 DVDD.t589 63.3219
R933 DVDD.n771 DVDD.t11 63.3219
R934 DVDD.n771 DVDD.t657 63.3219
R935 DVDD.n805 DVDD.t653 63.3219
R936 DVDD.n805 DVDD.t786 63.3219
R937 DVDD.n818 DVDD.t224 63.3219
R938 DVDD.n818 DVDD.t935 63.3219
R939 DVDD.n826 DVDD.t937 63.3219
R940 DVDD.n826 DVDD.t286 63.3219
R941 DVDD.n727 DVDD.t355 63.3219
R942 DVDD.n727 DVDD.t780 63.3219
R943 DVDD.n857 DVDD.t358 63.3219
R944 DVDD.n857 DVDD.t351 63.3219
R945 DVDD.n722 DVDD.t216 63.3219
R946 DVDD.n722 DVDD.t456 63.3219
R947 DVDD.n867 DVDD.t606 63.3219
R948 DVDD.n867 DVDD.t212 63.3219
R949 DVDD.n715 DVDD.t58 63.3219
R950 DVDD.n715 DVDD.t807 63.3219
R951 DVDD.n887 DVDD.t307 63.3219
R952 DVDD.n887 DVDD.t54 63.3219
R953 DVDD.n888 DVDD.t345 63.3219
R954 DVDD.n888 DVDD.t336 63.3219
R955 DVDD.n898 DVDD.t185 63.3219
R956 DVDD.n898 DVDD.t347 63.3219
R957 DVDD.t295 DVDD.t723 62.103
R958 DVDD.t912 DVDD.t566 62.103
R959 DVDD.t486 DVDD.t201 62.103
R960 DVDD.t436 DVDD.t462 62.103
R961 DVDD.t826 DVDD.t930 62.103
R962 DVDD.t880 DVDD.t889 60.4245
R963 DVDD.t839 DVDD.t522 60.4245
R964 DVDD.t582 DVDD.t586 60.4245
R965 DVDD.t556 DVDD.t364 58.7461
R966 DVDD.t125 DVDD.t898 58.7461
R967 DVDD.t723 DVDD.t745 58.7461
R968 DVDD.t465 DVDD.t636 58.7461
R969 DVDD.t201 DVDD.t328 58.7461
R970 DVDD.t943 DVDD.t436 58.7461
R971 DVDD.t930 DVDD.t12 58.7461
R972 DVDD.t362 DVDD.t599 58.7461
R973 DVDD.t747 DVDD.t317 57.0676
R974 DVDD.t290 DVDD.t331 57.0676
R975 DVDD.t162 DVDD.t135 57.0676
R976 DVDD.t202 DVDD.t402 57.0676
R977 DVDD.t849 DVDD.t799 57.0676
R978 DVDD.t352 DVDD.t111 57.0676
R979 DVDD.t121 DVDD.n440 53.7107
R980 DVDD.t558 DVDD.t642 53.7107
R981 DVDD.t706 DVDD.t590 53.7107
R982 DVDD.t46 DVDD.t127 52.0323
R983 DVDD.t580 DVDD.t510 52.0323
R984 DVDD.t623 DVDD.t708 52.0323
R985 DVDD.t227 DVDD.t872 50.3539
R986 DVDD.t682 DVDD.t492 50.3539
R987 DVDD.t487 DVDD.t512 50.3539
R988 DVDD.t530 DVDD.t38 50.3539
R989 DVDD.t279 DVDD.t544 46.997
R990 DVDD.t77 DVDD.t129 46.997
R991 DVDD.t45 DVDD.t432 46.997
R992 DVDD.t415 DVDD.t900 46.997
R993 DVDD.t482 DVDD.t875 45.3185
R994 DVDD.t683 DVDD.t574 45.3185
R995 DVDD.t823 DVDD.t142 45.3185
R996 DVDD.t484 DVDD.t755 45.3185
R997 DVDD.t806 DVDD.t180 45.3185
R998 DVDD.t406 DVDD.t876 43.6401
R999 DVDD.t686 DVDD.t924 43.6401
R1000 DVDD.t375 DVDD.t147 43.6401
R1001 DVDD.t313 DVDD.t459 43.6401
R1002 DVDD.t560 DVDD.t938 43.6401
R1003 DVDD.t426 DVDD.t84 43.6401
R1004 DVDD.t704 DVDD.t509 43.6401
R1005 DVDD.t51 DVDD.t184 43.6401
R1006 DVDD.n441 DVDD.t24 41.9616
R1007 DVDD.n842 DVDD.t795 41.9616
R1008 DVDD.t250 DVDD.t669 40.2832
R1009 DVDD.n580 DVDD.t833 40.2832
R1010 DVDD.t648 DVDD.n929 40.2832
R1011 DVDD.t22 DVDD.t597 38.6047
R1012 DVDD.t89 DVDD.t315 38.6047
R1013 DVDD.t511 DVDD.t166 38.6047
R1014 DVDD.t916 DVDD.t603 38.6047
R1015 DVDD.t159 DVDD.t213 38.6047
R1016 DVDD.t779 DVDD.t207 38.6047
R1017 DVDD.t891 DVDD.t759 36.9263
R1018 DVDD.t87 DVDD.t724 36.9263
R1019 DVDD.t284 DVDD.t174 36.9263
R1020 DVDD.n1106 DVDD.n1105 36.3167
R1021 DVDD.n330 DVDD.t34 35.2479
R1022 DVDD.t444 DVDD.n534 35.2479
R1023 DVDD.t498 DVDD.n1167 35.2479
R1024 DVDD.t422 DVDD.t221 35.2479
R1025 DVDD.n243 DVDD.n242 34.6358
R1026 DVDD.n214 DVDD.n213 34.6358
R1027 DVDD.n218 DVDD.n217 34.6358
R1028 DVDD.n211 DVDD.n202 34.6358
R1029 DVDD.n339 DVDD.n169 34.6358
R1030 DVDD.n339 DVDD.n338 34.6358
R1031 DVDD.n336 DVDD.n171 34.6358
R1032 DVDD.n332 DVDD.n171 34.6358
R1033 DVDD.n327 DVDD.n175 34.6358
R1034 DVDD.n323 DVDD.n322 34.6358
R1035 DVDD.n313 DVDD.n263 34.6358
R1036 DVDD.n309 DVDD.n308 34.6358
R1037 DVDD.n306 DVDD.n269 34.6358
R1038 DVDD.n300 DVDD.n273 34.6358
R1039 DVDD.n296 DVDD.n295 34.6358
R1040 DVDD.n295 DVDD.n294 34.6358
R1041 DVDD.n404 DVDD.n379 34.6358
R1042 DVDD.n410 DVDD.n375 34.6358
R1043 DVDD.n413 DVDD.n412 34.6358
R1044 DVDD.n417 DVDD.n416 34.6358
R1045 DVDD.n429 DVDD.n365 34.6358
R1046 DVDD.n352 DVDD.n351 34.6358
R1047 DVDD.n355 DVDD.n158 34.6358
R1048 DVDD.n438 DVDD.n159 34.6358
R1049 DVDD.n447 DVDD.n155 34.6358
R1050 DVDD.n451 DVDD.n450 34.6358
R1051 DVDD.n455 DVDD.n454 34.6358
R1052 DVDD.n473 DVDD.n147 34.6358
R1053 DVDD.n480 DVDD.n479 34.6358
R1054 DVDD.n485 DVDD.n143 34.6358
R1055 DVDD.n495 DVDD.n141 34.6358
R1056 DVDD.n501 DVDD.n498 34.6358
R1057 DVDD.n505 DVDD.n138 34.6358
R1058 DVDD.n509 DVDD.n507 34.6358
R1059 DVDD.n642 DVDD.n536 34.6358
R1060 DVDD.n628 DVDD.n540 34.6358
R1061 DVDD.n624 DVDD.n621 34.6358
R1062 DVDD.n618 DVDD.n543 34.6358
R1063 DVDD.n609 DVDD.n546 34.6358
R1064 DVDD.n604 DVDD.n603 34.6358
R1065 DVDD.n597 DVDD.n550 34.6358
R1066 DVDD.n593 DVDD.n588 34.6358
R1067 DVDD.n565 DVDD.n563 34.6358
R1068 DVDD.n569 DVDD.n568 34.6358
R1069 DVDD.n575 DVDD.n574 34.6358
R1070 DVDD.n579 DVDD.n578 34.6358
R1071 DVDD.n655 DVDD.n652 34.6358
R1072 DVDD.n659 DVDD.n529 34.6358
R1073 DVDD.n666 DVDD.n665 34.6358
R1074 DVDD.n669 DVDD.n524 34.6358
R1075 DVDD.n673 DVDD.n524 34.6358
R1076 DVDD.n674 DVDD.n673 34.6358
R1077 DVDD.n682 DVDD.n681 34.6358
R1078 DVDD.n1115 DVDD.n1114 34.6358
R1079 DVDD.n1119 DVDD.n121 34.6358
R1080 DVDD.n91 DVDD.n90 34.6358
R1081 DVDD.n84 DVDD.n22 34.6358
R1082 DVDD.n85 DVDD.n84 34.6358
R1083 DVDD.n87 DVDD.n85 34.6358
R1084 DVDD.n80 DVDD.n77 34.6358
R1085 DVDD.n75 DVDD.n24 34.6358
R1086 DVDD.n71 DVDD.n66 34.6358
R1087 DVDD.n57 DVDD.n30 34.6358
R1088 DVDD.n47 DVDD.n45 34.6358
R1089 DVDD.n43 DVDD.n39 34.6358
R1090 DVDD.n1178 DVDD.n6 34.6358
R1091 DVDD.n1178 DVDD.n1177 34.6358
R1092 DVDD.n1177 DVDD.n1176 34.6358
R1093 DVDD.n93 DVDD.n11 34.6358
R1094 DVDD.n1162 DVDD.n1161 34.6358
R1095 DVDD.n1153 DVDD.n1152 34.6358
R1096 DVDD.n1152 DVDD.n101 34.6358
R1097 DVDD.n1148 DVDD.n101 34.6358
R1098 DVDD.n1140 DVDD.n1139 34.6358
R1099 DVDD.n1040 DVDD.n1038 34.6358
R1100 DVDD.n1033 DVDD.n1032 34.6358
R1101 DVDD.n1023 DVDD.n944 34.6358
R1102 DVDD.n1026 DVDD.n1025 34.6358
R1103 DVDD.n1018 DVDD.n1017 34.6358
R1104 DVDD.n999 DVDD.n996 34.6358
R1105 DVDD.n1003 DVDD.n954 34.6358
R1106 DVDD.n990 DVDD.n989 34.6358
R1107 DVDD.n991 DVDD.n990 34.6358
R1108 DVDD.n985 DVDD.n984 34.6358
R1109 DVDD.n986 DVDD.n985 34.6358
R1110 DVDD.n1044 DVDD.n930 34.6358
R1111 DVDD.n1048 DVDD.n1047 34.6358
R1112 DVDD.n1052 DVDD.n1051 34.6358
R1113 DVDD.n1060 DVDD.n924 34.6358
R1114 DVDD.n1082 DVDD.n1081 34.6358
R1115 DVDD.n1085 DVDD.n915 34.6358
R1116 DVDD.n1089 DVDD.n915 34.6358
R1117 DVDD.n1097 DVDD.n1096 34.6358
R1118 DVDD.n1104 DVDD.n1103 34.6358
R1119 DVDD.n790 DVDD.n789 34.6358
R1120 DVDD.n797 DVDD.n796 34.6358
R1121 DVDD.n794 DVDD.n778 34.6358
R1122 DVDD.n801 DVDD.n769 34.6358
R1123 DVDD.n810 DVDD.n767 34.6358
R1124 DVDD.n813 DVDD.n812 34.6358
R1125 DVDD.n832 DVDD.n760 34.6358
R1126 DVDD.n828 DVDD.n760 34.6358
R1127 DVDD.n741 DVDD.n738 34.6358
R1128 DVDD.n745 DVDD.n738 34.6358
R1129 DVDD.n747 DVDD.n745 34.6358
R1130 DVDD.n751 DVDD.n736 34.6358
R1131 DVDD.n755 DVDD.n731 34.6358
R1132 DVDD.n839 DVDD.n732 34.6358
R1133 DVDD.n844 DVDD.n730 34.6358
R1134 DVDD.n848 DVDD.n728 34.6358
R1135 DVDD.n852 DVDD.n851 34.6358
R1136 DVDD.n856 DVDD.n855 34.6358
R1137 DVDD.n873 DVDD.n720 34.6358
R1138 DVDD.n879 DVDD.n878 34.6358
R1139 DVDD.n891 DVDD.n886 34.6358
R1140 DVDD.n895 DVDD.n713 34.6358
R1141 DVDD.n900 DVDD.n897 34.6358
R1142 DVDD.n904 DVDD.n711 34.6358
R1143 DVDD.n905 DVDD.n904 34.6358
R1144 DVDD.n252 DVDD.n174 34.2593
R1145 DVDD.n574 DVDD.n573 34.2593
R1146 DVDD.n1156 DVDD.n98 34.2593
R1147 DVDD.n1134 DVDD.n114 34.2593
R1148 DVDD.n998 DVDD.n954 33.8829
R1149 DVDD.n984 DVDD.n962 33.8829
R1150 DVDD.n1062 DVDD.n1061 33.8829
R1151 DVDD.n821 DVDD.n820 33.8829
R1152 DVDD.n753 DVDD.n752 33.8829
R1153 DVDD.t379 DVDD.t595 33.5694
R1154 DVDD.t25 DVDD.t272 33.5694
R1155 DVDD.t555 DVDD.t592 33.5694
R1156 DVDD.t350 DVDD.t215 33.5694
R1157 DVDD.t769 DVDD.t455 33.5694
R1158 DVDD.t361 DVDD.t600 33.5694
R1159 DVDD.n583 DVDD.n552 33.5064
R1160 DVDD.n1017 DVDD.n947 33.5064
R1161 DVDD.n1007 DVDD.n1006 33.5064
R1162 DVDD.n684 DVDD.n520 33.1299
R1163 DVDD.n1123 DVDD.n1122 33.1299
R1164 DVDD.n233 DVDD.n232 32.7534
R1165 DVDD.n207 DVDD.n205 32.7534
R1166 DVDD.n316 DVDD.n315 32.7534
R1167 DVDD.n419 DVDD.n368 32.7534
R1168 DVDD.n348 DVDD.n347 32.7534
R1169 DVDD.n462 DVDD.n150 32.7534
R1170 DVDD.n491 DVDD.n487 32.7534
R1171 DVDD.n614 DVDD.n610 32.7534
R1172 DVDD.n662 DVDD.n661 32.7534
R1173 DVDD.n64 DVDD.n27 32.7534
R1174 DVDD.n1172 DVDD.n8 32.7534
R1175 DVDD.n973 DVDD.n972 32.7534
R1176 DVDD.n1030 DVDD.n937 32.7534
R1177 DVDD.n1078 DVDD.n1076 32.7534
R1178 DVDD.n827 DVDD.n825 32.7534
R1179 DVDD.n863 DVDD.n723 32.7534
R1180 DVDD.n884 DVDD.n716 32.7534
R1181 DVDD.t739 DVDD.t668 31.891
R1182 DVDD.t248 DVDD.t232 31.891
R1183 DVDD.t532 DVDD.t622 31.891
R1184 DVDD.n1012 DVDD.n1011 30.8711
R1185 DVDD.t741 DVDD.t546 30.2125
R1186 DVDD.t442 DVDD.t74 30.2125
R1187 DVDD.t733 DVDD.t568 30.2125
R1188 DVDD.n231 DVDD.n188 29.7417
R1189 DVDD.n337 DVDD.n336 29.7417
R1190 DVDD.n481 DVDD.n143 29.7417
R1191 DVDD.n605 DVDD.n546 29.7417
R1192 DVDD.n6 DVDD.n5 29.7417
R1193 DVDD.n1133 DVDD.n1132 29.7417
R1194 DVDD.n1038 DVDD.n1037 29.7417
R1195 DVDD.n813 DVDD.n765 29.7417
R1196 DVDD.n835 DVDD.n834 29.7417
R1197 DVDD.n875 DVDD.n874 29.7417
R1198 DVDD.n764 DVDD.t633 28.752
R1199 DVDD.t181 DVDD.t757 28.5341
R1200 DVDD.n979 DVDD.n978 27.8593
R1201 DVDD.n996 DVDD.n995 27.8593
R1202 DVDD.n1055 DVDD.n924 27.8593
R1203 DVDD.n1103 DVDD.n911 27.8593
R1204 DVDD.n746 DVDD.n736 27.8593
R1205 DVDD.n257 DVDD.n175 27.1064
R1206 DVDD.n432 DVDD.n431 27.1064
R1207 DVDD.n638 DVDD.n637 27.1064
R1208 DVDD.n569 DVDD.n557 27.1064
R1209 DVDD.n991 DVDD.n956 27.1064
R1210 DVDD.t37 DVDD.t63 26.8556
R1211 DVDD.t251 DVDD.t115 26.8556
R1212 DVDD.t709 DVDD.t65 26.8556
R1213 DVDD.t86 DVDD.t618 26.8556
R1214 DVDD.t714 DVDD.t59 26.8556
R1215 DVDD.t20 DVDD.t626 26.8556
R1216 DVDD.t4 DVDD.t8 26.8556
R1217 DVDD.t152 DVDD.t628 26.8556
R1218 DVDD.t21 DVDD.t6 26.8556
R1219 DVDD.t150 DVDD.t624 26.8556
R1220 DVDD.n961 DVDD.t179 26.5955
R1221 DVDD.n961 DVDD.t177 26.5955
R1222 DVDD.n950 DVDD.t117 26.5955
R1223 DVDD.n950 DVDD.t414 26.5955
R1224 DVDD.n997 DVDD.t210 26.5955
R1225 DVDD.n997 DVDD.t214 26.5955
R1226 DVDD.n923 DVDD.t561 26.5955
R1227 DVDD.n923 DVDD.t559 26.5955
R1228 DVDD.n910 DVDD.t705 26.5955
R1229 DVDD.n910 DVDD.t707 26.5955
R1230 DVDD.n735 DVDD.t858 26.5955
R1231 DVDD.n735 DVDD.t862 26.5955
R1232 DVDD.n285 DVDD.n284 25.977
R1233 DVDD.n250 DVDD.n249 25.977
R1234 DVDD.n301 DVDD.n300 25.977
R1235 DVDD.n290 DVDD.n289 25.977
R1236 DVDD.n397 DVDD.n388 25.977
R1237 DVDD.n405 DVDD.n404 25.977
R1238 DVDD.n695 DVDD.n517 25.977
R1239 DVDD.n699 DVDD.n515 25.977
R1240 DVDD.n706 DVDD.n704 25.977
R1241 DVDD.n1128 DVDD.n1127 25.977
R1242 DVDD.n1070 DVDD.n919 25.977
R1243 DVDD.t516 DVDD.t885 25.1772
R1244 DVDD.t474 DVDD.t703 25.1772
R1245 DVDD.t837 DVDD.t928 25.1772
R1246 DVDD.t773 DVDD.t265 25.1772
R1247 DVDD.t552 DVDD.t411 25.1772
R1248 DVDD.t373 DVDD.t676 25.1772
R1249 DVDD.t907 DVDD.t494 25.1772
R1250 DVDD.t310 DVDD.t254 25.1772
R1251 DVDD.t289 DVDD.t41 25.1772
R1252 DVDD.t357 DVDD.t339 25.1772
R1253 DVDD.t57 DVDD.t342 25.1772
R1254 DVDD.t311 DVDD.t338 25.1772
R1255 DVDD.n284 DVDD.n283 24.4711
R1256 DVDD.n322 DVDD.n321 24.4711
R1257 DVDD.n289 DVDD.n281 24.4711
R1258 DVDD.n393 DVDD.n388 24.4711
R1259 DVDD.n425 DVDD.n365 24.4711
R1260 DVDD.n474 DVDD.n473 24.4711
R1261 DVDD.n643 DVDD.n642 24.4711
R1262 DVDD.n635 DVDD.n634 24.4711
R1263 DVDD.n598 DVDD.n597 24.4711
R1264 DVDD.n691 DVDD.n690 24.4711
R1265 DVDD.n703 DVDD.n515 24.4711
R1266 DVDD.n1114 DVDD.n1113 24.4711
R1267 DVDD.n58 DVDD.n57 24.4711
R1268 DVDD.n1074 DVDD.n919 24.4711
R1269 DVDD.n448 DVDD.n447 24.0946
R1270 DVDD.n678 DVDD.n677 24.0946
R1271 DVDD.n1127 DVDD.n119 24.0946
R1272 DVDD.n1165 DVDD.n13 24.0946
R1273 DVDD.n1004 DVDD.n1003 24.0946
R1274 DVDD.n849 DVDD.n848 24.0946
R1275 DVDD.n249 DVDD.n248 23.7181
R1276 DVDD.n227 DVDD.n226 23.7181
R1277 DVDD.n224 DVDD.n223 23.7181
R1278 DVDD.n321 DVDD.n320 23.7181
R1279 DVDD.n302 DVDD.n301 23.7181
R1280 DVDD.n291 DVDD.n290 23.7181
R1281 DVDD.n398 DVDD.n397 23.7181
R1282 DVDD.n406 DVDD.n405 23.7181
R1283 DVDD.n425 DVDD.n424 23.7181
R1284 DVDD.n443 DVDD.n157 23.7181
R1285 DVDD.n476 DVDD.n474 23.7181
R1286 DVDD.n638 DVDD.n635 23.7181
R1287 DVDD.n631 DVDD.n630 23.7181
R1288 DVDD.n600 DVDD.n598 23.7181
R1289 DVDD.n563 DVDD.n562 23.7181
R1290 DVDD.n644 DVDD.n643 23.7181
R1291 DVDD.n59 DVDD.n58 23.7181
R1292 DVDD.n51 DVDD.n50 23.7181
R1293 DVDD.n1129 DVDD.n1128 23.7181
R1294 DVDD.n1064 DVDD.n921 23.7181
R1295 DVDD.n137 DVDD.n136 23.5284
R1296 DVDD.n699 DVDD.n698 23.3417
R1297 DVDD.t471 DVDD.t548 20.1418
R1298 DVDD.t476 DVDD.t887 20.1418
R1299 DVDD.t520 DVDD.t701 20.1418
R1300 DVDD.t485 DVDD.t873 20.1418
R1301 DVDD.t841 DVDD.t267 20.1418
R1302 DVDD.t815 DVDD.t926 20.1418
R1303 DVDD.t684 DVDD.t573 20.1418
R1304 DVDD.t909 DVDD.t678 20.1418
R1305 DVDD.t369 DVDD.t495 20.1418
R1306 DVDD.t813 DVDD.t145 20.1418
R1307 DVDD.t306 DVDD.t344 20.1418
R1308 DVDD.t53 DVDD.t335 20.1418
R1309 DVDD.t771 DVDD.t182 20.1418
R1310 DVDD.n226 DVDD.n225 19.577
R1311 DVDD.n267 DVDD.n263 19.577
R1312 DVDD.n391 DVDD.n157 19.577
R1313 DVDD.n416 DVDD.n371 19.577
R1314 DVDD.n469 DVDD.n468 19.577
R1315 DVDD.n667 DVDD.n666 19.577
R1316 DVDD.n689 DVDD.n688 19.577
R1317 DVDD.n71 DVDD.n70 19.577
R1318 DVDD.n1156 DVDD.n1155 19.577
R1319 DVDD.n1139 DVDD.n1138 19.577
R1320 DVDD.n980 DVDD.n979 19.577
R1321 DVDD.n1013 DVDD.n1012 19.577
R1322 DVDD.n1069 DVDD.n1068 19.577
R1323 DVDD.n891 DVDD.n890 19.577
R1324 DVDD.n592 DVDD.n591 19.2005
R1325 DVDD.n125 DVDD.n124 19.2005
R1326 DVDD.t518 DVDD.t452 18.4634
R1327 DVDD.t197 DVDD.t922 18.4634
R1328 DVDD.t609 DVDD.t713 18.4634
R1329 DVDD.t18 DVDD.t853 18.4634
R1330 DVDD.t91 DVDD.t367 18.4634
R1331 DVDD.t48 DVDD.t430 18.4634
R1332 DVDD.t371 DVDD.t199 18.4634
R1333 DVDD.t851 DVDD.t209 18.4634
R1334 DVDD.t602 DVDD.t607 18.4634
R1335 DVDD.t785 DVDD.t859 18.4634
R1336 DVDD.n251 DVDD.n250 18.4476
R1337 DVDD.n476 DVDD.n475 18.4476
R1338 DVDD.n600 DVDD.n599 18.4476
R1339 DVDD.n565 DVDD.n564 18.4476
R1340 DVDD.n696 DVDD.n695 18.4476
R1341 DVDD.n706 DVDD.n705 18.4476
R1342 DVDD.n87 DVDD.n86 18.4476
R1343 DVDD.n47 DVDD.n46 18.4476
R1344 DVDD.n164 DVDD.n163 18.0986
R1345 DVDD.n968 DVDD.n967 18.0979
R1346 DVDD.n276 DVDD.n275 18.0711
R1347 DVDD.n280 DVDD.n278 18.0711
R1348 DVDD.n382 DVDD.n381 18.0711
R1349 DVDD.n491 DVDD.n490 18.0711
R1350 DVDD.n496 DVDD.n495 18.0711
R1351 DVDD.n619 DVDD.n618 18.0711
R1352 DVDD.n614 DVDD.n613 18.0711
R1353 DVDD.n587 DVDD.n586 18.0711
R1354 DVDD.n683 DVDD.n682 18.0711
R1355 DVDD.n1121 DVDD.n1120 18.0711
R1356 DVDD.n1161 DVDD.n1160 18.0711
R1357 DVDD.n1143 DVDD.n110 18.0711
R1358 DVDD.n1078 DVDD.n1077 18.0711
R1359 DVDD.n825 DVDD.n762 18.0711
R1360 DVDD.n168 DVDD.n167 17.9865
R1361 DVDD.n740 DVDD.n739 17.9863
R1362 DVDD.n214 DVDD.n199 17.3181
R1363 DVDD.n217 DVDD.n199 17.3181
R1364 DVDD.n332 DVDD.n331 17.3181
R1365 DVDD.n331 DVDD.n173 17.3181
R1366 DVDD.n328 DVDD.n174 17.3181
R1367 DVDD.n328 DVDD.n327 17.3181
R1368 DVDD.n400 DVDD.n399 17.3181
R1369 DVDD.n399 DVDD.n398 17.3181
R1370 DVDD.n434 DVDD.n433 17.3181
R1371 DVDD.n433 DVDD.n432 17.3181
R1372 DVDD.n439 DVDD.n158 17.3181
R1373 DVDD.n439 DVDD.n438 17.3181
R1374 DVDD.n443 DVDD.n442 17.3181
R1375 DVDD.n442 DVDD.n155 17.3181
R1376 DVDD.n581 DVDD.n579 17.3181
R1377 DVDD.n645 DVDD.n644 17.3181
R1378 DVDD.n646 DVDD.n645 17.3181
R1379 DVDD.n1170 DVDD.n1169 17.3181
R1380 DVDD.n1169 DVDD.n10 17.3181
R1381 DVDD.n92 DVDD.n91 17.3181
R1382 DVDD.n93 DVDD.n92 17.3181
R1383 DVDD.n1166 DVDD.n11 17.3181
R1384 DVDD.n1166 DVDD.n1165 17.3181
R1385 DVDD.n1144 DVDD.n1143 17.3181
R1386 DVDD.n1024 DVDD.n1023 17.3181
R1387 DVDD.n1025 DVDD.n1024 17.3181
R1388 DVDD.n1045 DVDD.n1044 17.3181
R1389 DVDD.n796 DVDD.n795 17.3181
R1390 DVDD.n795 DVDD.n794 17.3181
R1391 DVDD.n834 DVDD.n833 17.3181
R1392 DVDD.n833 DVDD.n832 17.3181
R1393 DVDD.n754 DVDD.n753 17.3181
R1394 DVDD.n755 DVDD.n754 17.3181
R1395 DVDD.n840 DVDD.n731 17.3181
R1396 DVDD.n840 DVDD.n839 17.3181
R1397 DVDD.n844 DVDD.n843 17.3181
R1398 DVDD.n843 DVDD.n728 17.3181
R1399 DVDD.t95 DVDD.t765 16.785
R1400 DVDD.t300 DVDD.t141 16.785
R1401 DVDD.n588 DVDD.n587 16.5652
R1402 DVDD.n685 DVDD.n683 16.5652
R1403 DVDD.n1120 DVDD.n1119 16.5652
R1404 DVDD.n1160 DVDD.n1159 16.5652
R1405 DVDD.n822 DVDD.n762 16.5652
R1406 DVDD.n253 DVDD.n251 16.1887
R1407 DVDD.n400 DVDD.n382 16.1887
R1408 DVDD.n697 DVDD.n696 16.1887
R1409 DVDD.n705 DVDD.n514 16.1887
R1410 DVDD.n53 DVDD.n33 16.1887
R1411 DVDD.n291 DVDD.n280 16.1887
R1412 DVDD.n508 DVDD.n137 16.077
R1413 DVDD.n52 DVDD.n51 15.8123
R1414 DVDD.n1145 DVDD.n1144 15.4358
R1415 DVDD.n112 DVDD.n110 15.4358
R1416 DVDD.t690 DVDD.t0 15.1065
R1417 DVDD.n277 DVDD.n276 15.0593
R1418 DVDD.n498 DVDD.n497 15.0593
R1419 DVDD.n621 DVDD.n620 15.0593
R1420 DVDD.n564 DVDD.n559 15.0593
R1421 DVDD.n690 DVDD.n689 15.0593
R1422 DVDD.n46 DVDD.n35 15.0593
R1423 DVDD.n1138 DVDD.n1137 15.0593
R1424 DVDD.n1014 DVDD.n1013 15.0593
R1425 DVDD.n981 DVDD.n980 15.0593
R1426 DVDD.n227 DVDD.n188 14.6829
R1427 DVDD.n338 DVDD.n337 14.6829
R1428 DVDD.n320 DVDD.n260 14.6829
R1429 DVDD.n424 DVDD.n423 14.6829
R1430 DVDD.n481 DVDD.n480 14.6829
R1431 DVDD.n605 DVDD.n604 14.6829
R1432 DVDD.n60 DVDD.n59 14.6829
R1433 DVDD.n1134 DVDD.n1133 14.6829
R1434 DVDD.n1037 DVDD.n1036 14.6829
R1435 DVDD.n1019 DVDD.n1018 14.6829
R1436 DVDD.n789 DVDD.n788 14.6829
R1437 DVDD.n817 DVDD.n765 14.6829
R1438 DVDD.n835 DVDD.n732 14.6829
R1439 DVDD.n874 DVDD.n873 14.6829
R1440 DVDD.n880 DVDD.n879 14.6829
R1441 DVDD.n468 DVDD.n467 13.9299
R1442 DVDD.n591 DVDD.n590 13.9299
R1443 DVDD.n126 DVDD.n125 13.9299
R1444 DVDD.n53 DVDD.n52 13.5534
R1445 DVDD.t404 DVDD.t229 13.4281
R1446 DVDD.n285 DVDD.n281 12.8005
R1447 DVDD.n393 DVDD.n392 12.8005
R1448 DVDD.n650 DVDD.n532 12.8005
R1449 DVDD.n691 DVDD.n517 12.8005
R1450 DVDD.n704 DVDD.n703 12.8005
R1451 DVDD.n1113 DVDD.n127 12.8005
R1452 DVDD.n1070 DVDD.n1069 12.8005
R1453 DVDD.n129 DVDD.n128 12.0466
R1454 DVDD.t762 DVDD.t450 11.7496
R1455 DVDD.t10 DVDD.t258 11.7496
R1456 DVDD.n237 DVDD.n236 11.6711
R1457 DVDD.n232 DVDD.n231 11.6711
R1458 DVDD.n205 DVDD.n173 11.6711
R1459 DVDD.n347 DVDD.n345 11.6711
R1460 DVDD.n458 DVDD.n150 11.6711
R1461 DVDD.n487 DVDD.n485 11.6711
R1462 DVDD.n610 DVDD.n609 11.6711
R1463 DVDD.n646 DVDD.n532 11.6711
R1464 DVDD.n661 DVDD.n659 11.6711
R1465 DVDD.n1176 DVDD.n8 11.6711
R1466 DVDD.n1146 DVDD.n1145 11.6711
R1467 DVDD.n972 DVDD.n970 11.6711
R1468 DVDD.n1026 DVDD.n937 11.6711
R1469 DVDD.n1091 DVDD.n1089 11.6711
R1470 DVDD.n806 DVDD.n767 11.6711
R1471 DVDD.n828 DVDD.n827 11.6711
R1472 DVDD.n859 DVDD.n723 11.6711
R1473 DVDD.n907 DVDD.n906 10.7167
R1474 DVDD.n220 DVDD.n192 10.5417
R1475 DVDD.n309 DVDD.n268 10.5417
R1476 DVDD.n413 DVDD.n374 10.5417
R1477 DVDD.n489 DVDD.n141 10.5417
R1478 DVDD.n612 DVDD.n543 10.5417
R1479 DVDD.n575 DVDD.n555 10.5417
R1480 DVDD.n583 DVDD.n582 10.5417
R1481 DVDD.n1124 DVDD.n119 10.5417
R1482 DVDD.n69 DVDD.n24 10.5417
R1483 DVDD.n44 DVDD.n43 10.5417
R1484 DVDD.n1005 DVDD.n1004 10.5417
R1485 DVDD.n1047 DVDD.n1046 10.5417
R1486 DVDD.n889 DVDD.n713 10.5417
R1487 DVDD.n906 DVDD.n905 10.5417
R1488 DVDD.n707 DVDD.n514 9.42029
R1489 DVDD.n677 DVDD.n522 9.41227
R1490 DVDD.n97 DVDD.n13 9.41227
R1491 DVDD.n290 DVDD.n279 9.3005
R1492 DVDD.n287 DVDD.n281 9.3005
R1493 DVDD.n286 DVDD.n285 9.3005
R1494 DVDD.n284 DVDD.n282 9.3005
R1495 DVDD.n289 DVDD.n288 9.3005
R1496 DVDD.n292 DVDD.n291 9.3005
R1497 DVDD.n294 DVDD.n293 9.3005
R1498 DVDD.n169 DVDD.n165 9.3005
R1499 DVDD.n340 DVDD.n339 9.3005
R1500 DVDD.n338 DVDD.n166 9.3005
R1501 DVDD.n337 DVDD.n170 9.3005
R1502 DVDD.n336 DVDD.n335 9.3005
R1503 DVDD.n334 DVDD.n171 9.3005
R1504 DVDD.n333 DVDD.n332 9.3005
R1505 DVDD.n173 DVDD.n172 9.3005
R1506 DVDD.n205 DVDD.n203 9.3005
R1507 DVDD.n208 DVDD.n207 9.3005
R1508 DVDD.n209 DVDD.n202 9.3005
R1509 DVDD.n211 DVDD.n210 9.3005
R1510 DVDD.n213 DVDD.n200 9.3005
R1511 DVDD.n215 DVDD.n214 9.3005
R1512 DVDD.n217 DVDD.n216 9.3005
R1513 DVDD.n218 DVDD.n193 9.3005
R1514 DVDD.n221 DVDD.n220 9.3005
R1515 DVDD.n223 DVDD.n222 9.3005
R1516 DVDD.n224 DVDD.n191 9.3005
R1517 DVDD.n225 DVDD.n190 9.3005
R1518 DVDD.n226 DVDD.n189 9.3005
R1519 DVDD.n228 DVDD.n227 9.3005
R1520 DVDD.n229 DVDD.n188 9.3005
R1521 DVDD.n231 DVDD.n230 9.3005
R1522 DVDD.n232 DVDD.n186 9.3005
R1523 DVDD.n234 DVDD.n233 9.3005
R1524 DVDD.n236 DVDD.n235 9.3005
R1525 DVDD.n237 DVDD.n182 9.3005
R1526 DVDD.n240 DVDD.n239 9.3005
R1527 DVDD.n242 DVDD.n241 9.3005
R1528 DVDD.n243 DVDD.n179 9.3005
R1529 DVDD.n246 DVDD.n245 9.3005
R1530 DVDD.n248 DVDD.n247 9.3005
R1531 DVDD.n249 DVDD.n177 9.3005
R1532 DVDD.n250 DVDD.n176 9.3005
R1533 DVDD.n254 DVDD.n253 9.3005
R1534 DVDD.n255 DVDD.n174 9.3005
R1535 DVDD.n327 DVDD.n326 9.3005
R1536 DVDD.n325 DVDD.n175 9.3005
R1537 DVDD.n324 DVDD.n323 9.3005
R1538 DVDD.n322 DVDD.n256 9.3005
R1539 DVDD.n321 DVDD.n259 9.3005
R1540 DVDD.n320 DVDD.n319 9.3005
R1541 DVDD.n318 DVDD.n260 9.3005
R1542 DVDD.n317 DVDD.n316 9.3005
R1543 DVDD.n315 DVDD.n261 9.3005
R1544 DVDD.n313 DVDD.n312 9.3005
R1545 DVDD.n311 DVDD.n263 9.3005
R1546 DVDD.n310 DVDD.n309 9.3005
R1547 DVDD.n308 DVDD.n264 9.3005
R1548 DVDD.n306 DVDD.n305 9.3005
R1549 DVDD.n304 DVDD.n269 9.3005
R1550 DVDD.n303 DVDD.n302 9.3005
R1551 DVDD.n301 DVDD.n270 9.3005
R1552 DVDD.n300 DVDD.n299 9.3005
R1553 DVDD.n298 DVDD.n273 9.3005
R1554 DVDD.n297 DVDD.n296 9.3005
R1555 DVDD.n295 DVDD.n274 9.3005
R1556 DVDD.n510 DVDD.n509 9.3005
R1557 DVDD.n507 DVDD.n131 9.3005
R1558 DVDD.n505 DVDD.n504 9.3005
R1559 DVDD.n503 DVDD.n138 9.3005
R1560 DVDD.n502 DVDD.n501 9.3005
R1561 DVDD.n498 DVDD.n139 9.3005
R1562 DVDD.n495 DVDD.n494 9.3005
R1563 DVDD.n493 DVDD.n141 9.3005
R1564 DVDD.n492 DVDD.n491 9.3005
R1565 DVDD.n487 DVDD.n142 9.3005
R1566 DVDD.n485 DVDD.n484 9.3005
R1567 DVDD.n483 DVDD.n143 9.3005
R1568 DVDD.n482 DVDD.n481 9.3005
R1569 DVDD.n480 DVDD.n144 9.3005
R1570 DVDD.n479 DVDD.n478 9.3005
R1571 DVDD.n477 DVDD.n476 9.3005
R1572 DVDD.n474 DVDD.n146 9.3005
R1573 DVDD.n345 DVDD.n344 9.3005
R1574 DVDD.n347 DVDD.n162 9.3005
R1575 DVDD.n349 DVDD.n348 9.3005
R1576 DVDD.n351 DVDD.n350 9.3005
R1577 DVDD.n352 DVDD.n160 9.3005
R1578 DVDD.n356 DVDD.n355 9.3005
R1579 DVDD.n357 DVDD.n158 9.3005
R1580 DVDD.n438 DVDD.n437 9.3005
R1581 DVDD.n436 DVDD.n159 9.3005
R1582 DVDD.n435 DVDD.n434 9.3005
R1583 DVDD.n432 DVDD.n358 9.3005
R1584 DVDD.n429 DVDD.n428 9.3005
R1585 DVDD.n427 DVDD.n365 9.3005
R1586 DVDD.n426 DVDD.n425 9.3005
R1587 DVDD.n424 DVDD.n366 9.3005
R1588 DVDD.n423 DVDD.n422 9.3005
R1589 DVDD.n421 DVDD.n368 9.3005
R1590 DVDD.n420 DVDD.n419 9.3005
R1591 DVDD.n417 DVDD.n369 9.3005
R1592 DVDD.n416 DVDD.n415 9.3005
R1593 DVDD.n414 DVDD.n413 9.3005
R1594 DVDD.n412 DVDD.n372 9.3005
R1595 DVDD.n410 DVDD.n409 9.3005
R1596 DVDD.n408 DVDD.n375 9.3005
R1597 DVDD.n407 DVDD.n406 9.3005
R1598 DVDD.n405 DVDD.n376 9.3005
R1599 DVDD.n404 DVDD.n403 9.3005
R1600 DVDD.n402 DVDD.n379 9.3005
R1601 DVDD.n401 DVDD.n400 9.3005
R1602 DVDD.n398 DVDD.n380 9.3005
R1603 DVDD.n397 DVDD.n396 9.3005
R1604 DVDD.n395 DVDD.n388 9.3005
R1605 DVDD.n394 DVDD.n393 9.3005
R1606 DVDD.n392 DVDD.n389 9.3005
R1607 DVDD.n391 DVDD.n390 9.3005
R1608 DVDD.n157 DVDD.n156 9.3005
R1609 DVDD.n444 DVDD.n443 9.3005
R1610 DVDD.n445 DVDD.n155 9.3005
R1611 DVDD.n447 DVDD.n446 9.3005
R1612 DVDD.n450 DVDD.n153 9.3005
R1613 DVDD.n452 DVDD.n451 9.3005
R1614 DVDD.n454 DVDD.n453 9.3005
R1615 DVDD.n455 DVDD.n151 9.3005
R1616 DVDD.n459 DVDD.n458 9.3005
R1617 DVDD.n460 DVDD.n150 9.3005
R1618 DVDD.n462 DVDD.n461 9.3005
R1619 DVDD.n464 DVDD.n148 9.3005
R1620 DVDD.n470 DVDD.n469 9.3005
R1621 DVDD.n471 DVDD.n147 9.3005
R1622 DVDD.n473 DVDD.n472 9.3005
R1623 DVDD.n563 DVDD.n560 9.3005
R1624 DVDD.n566 DVDD.n565 9.3005
R1625 DVDD.n568 DVDD.n567 9.3005
R1626 DVDD.n570 DVDD.n569 9.3005
R1627 DVDD.n572 DVDD.n571 9.3005
R1628 DVDD.n574 DVDD.n556 9.3005
R1629 DVDD.n576 DVDD.n575 9.3005
R1630 DVDD.n578 DVDD.n577 9.3005
R1631 DVDD.n579 DVDD.n553 9.3005
R1632 DVDD.n584 DVDD.n583 9.3005
R1633 DVDD.n586 DVDD.n585 9.3005
R1634 DVDD.n588 DVDD.n551 9.3005
R1635 DVDD.n594 DVDD.n593 9.3005
R1636 DVDD.n595 DVDD.n550 9.3005
R1637 DVDD.n597 DVDD.n596 9.3005
R1638 DVDD.n598 DVDD.n549 9.3005
R1639 DVDD.n601 DVDD.n600 9.3005
R1640 DVDD.n603 DVDD.n602 9.3005
R1641 DVDD.n604 DVDD.n547 9.3005
R1642 DVDD.n606 DVDD.n605 9.3005
R1643 DVDD.n607 DVDD.n546 9.3005
R1644 DVDD.n609 DVDD.n608 9.3005
R1645 DVDD.n610 DVDD.n544 9.3005
R1646 DVDD.n615 DVDD.n614 9.3005
R1647 DVDD.n616 DVDD.n543 9.3005
R1648 DVDD.n618 DVDD.n617 9.3005
R1649 DVDD.n621 DVDD.n541 9.3005
R1650 DVDD.n625 DVDD.n624 9.3005
R1651 DVDD.n626 DVDD.n540 9.3005
R1652 DVDD.n628 DVDD.n627 9.3005
R1653 DVDD.n630 DVDD.n539 9.3005
R1654 DVDD.n632 DVDD.n631 9.3005
R1655 DVDD.n634 DVDD.n633 9.3005
R1656 DVDD.n635 DVDD.n537 9.3005
R1657 DVDD.n639 DVDD.n638 9.3005
R1658 DVDD.n640 DVDD.n536 9.3005
R1659 DVDD.n642 DVDD.n641 9.3005
R1660 DVDD.n643 DVDD.n535 9.3005
R1661 DVDD.n644 DVDD.n533 9.3005
R1662 DVDD.n647 DVDD.n646 9.3005
R1663 DVDD.n648 DVDD.n532 9.3005
R1664 DVDD.n650 DVDD.n649 9.3005
R1665 DVDD.n652 DVDD.n530 9.3005
R1666 DVDD.n656 DVDD.n655 9.3005
R1667 DVDD.n657 DVDD.n529 9.3005
R1668 DVDD.n659 DVDD.n658 9.3005
R1669 DVDD.n661 DVDD.n528 9.3005
R1670 DVDD.n663 DVDD.n662 9.3005
R1671 DVDD.n665 DVDD.n664 9.3005
R1672 DVDD.n666 DVDD.n525 9.3005
R1673 DVDD.n670 DVDD.n669 9.3005
R1674 DVDD.n671 DVDD.n524 9.3005
R1675 DVDD.n673 DVDD.n672 9.3005
R1676 DVDD.n674 DVDD.n523 9.3005
R1677 DVDD.n679 DVDD.n678 9.3005
R1678 DVDD.n681 DVDD.n680 9.3005
R1679 DVDD.n682 DVDD.n521 9.3005
R1680 DVDD.n686 DVDD.n685 9.3005
R1681 DVDD.n688 DVDD.n687 9.3005
R1682 DVDD.n690 DVDD.n518 9.3005
R1683 DVDD.n692 DVDD.n691 9.3005
R1684 DVDD.n693 DVDD.n517 9.3005
R1685 DVDD.n695 DVDD.n694 9.3005
R1686 DVDD.n697 DVDD.n516 9.3005
R1687 DVDD.n700 DVDD.n699 9.3005
R1688 DVDD.n701 DVDD.n515 9.3005
R1689 DVDD.n703 DVDD.n702 9.3005
R1690 DVDD.n704 DVDD.n513 9.3005
R1691 DVDD.n707 DVDD.n706 9.3005
R1692 DVDD.n1128 DVDD.n117 9.3005
R1693 DVDD.n1125 DVDD.n1124 9.3005
R1694 DVDD.n1121 DVDD.n120 9.3005
R1695 DVDD.n1117 DVDD.n121 9.3005
R1696 DVDD.n1116 DVDD.n1115 9.3005
R1697 DVDD.n1113 DVDD.n1112 9.3005
R1698 DVDD.n1111 DVDD.n127 9.3005
R1699 DVDD.n1114 DVDD.n122 9.3005
R1700 DVDD.n1119 DVDD.n1118 9.3005
R1701 DVDD.n1127 DVDD.n1126 9.3005
R1702 DVDD.n1130 DVDD.n1129 9.3005
R1703 DVDD.n1132 DVDD.n1131 9.3005
R1704 DVDD.n1133 DVDD.n115 9.3005
R1705 DVDD.n1135 DVDD.n1134 9.3005
R1706 DVDD.n1137 DVDD.n1136 9.3005
R1707 DVDD.n6 DVDD.n2 9.3005
R1708 DVDD.n1179 DVDD.n1178 9.3005
R1709 DVDD.n1177 DVDD.n3 9.3005
R1710 DVDD.n1176 DVDD.n1175 9.3005
R1711 DVDD.n1174 DVDD.n8 9.3005
R1712 DVDD.n1173 DVDD.n1172 9.3005
R1713 DVDD.n1170 DVDD.n9 9.3005
R1714 DVDD.n40 DVDD.n10 9.3005
R1715 DVDD.n41 DVDD.n39 9.3005
R1716 DVDD.n43 DVDD.n42 9.3005
R1717 DVDD.n45 DVDD.n36 9.3005
R1718 DVDD.n48 DVDD.n47 9.3005
R1719 DVDD.n50 DVDD.n49 9.3005
R1720 DVDD.n51 DVDD.n34 9.3005
R1721 DVDD.n52 DVDD.n31 9.3005
R1722 DVDD.n54 DVDD.n53 9.3005
R1723 DVDD.n55 DVDD.n30 9.3005
R1724 DVDD.n57 DVDD.n56 9.3005
R1725 DVDD.n58 DVDD.n29 9.3005
R1726 DVDD.n59 DVDD.n28 9.3005
R1727 DVDD.n61 DVDD.n60 9.3005
R1728 DVDD.n62 DVDD.n27 9.3005
R1729 DVDD.n64 DVDD.n63 9.3005
R1730 DVDD.n66 DVDD.n25 9.3005
R1731 DVDD.n72 DVDD.n71 9.3005
R1732 DVDD.n73 DVDD.n24 9.3005
R1733 DVDD.n75 DVDD.n74 9.3005
R1734 DVDD.n77 DVDD.n23 9.3005
R1735 DVDD.n81 DVDD.n80 9.3005
R1736 DVDD.n82 DVDD.n22 9.3005
R1737 DVDD.n84 DVDD.n83 9.3005
R1738 DVDD.n85 DVDD.n21 9.3005
R1739 DVDD.n88 DVDD.n87 9.3005
R1740 DVDD.n90 DVDD.n89 9.3005
R1741 DVDD.n91 DVDD.n14 9.3005
R1742 DVDD.n94 DVDD.n93 9.3005
R1743 DVDD.n95 DVDD.n11 9.3005
R1744 DVDD.n1165 DVDD.n1164 9.3005
R1745 DVDD.n1163 DVDD.n1162 9.3005
R1746 DVDD.n1161 DVDD.n96 9.3005
R1747 DVDD.n1159 DVDD.n1158 9.3005
R1748 DVDD.n1157 DVDD.n1156 9.3005
R1749 DVDD.n1153 DVDD.n99 9.3005
R1750 DVDD.n1152 DVDD.n1151 9.3005
R1751 DVDD.n1150 DVDD.n101 9.3005
R1752 DVDD.n1149 DVDD.n1148 9.3005
R1753 DVDD.n1146 DVDD.n102 9.3005
R1754 DVDD.n1145 DVDD.n103 9.3005
R1755 DVDD.n1143 DVDD.n1142 9.3005
R1756 DVDD.n1141 DVDD.n1140 9.3005
R1757 DVDD.n1139 DVDD.n111 9.3005
R1758 DVDD.n1104 DVDD.n909 9.3005
R1759 DVDD.n1103 DVDD.n1102 9.3005
R1760 DVDD.n1101 DVDD.n1100 9.3005
R1761 DVDD.n1097 DVDD.n912 9.3005
R1762 DVDD.n1096 DVDD.n1095 9.3005
R1763 DVDD.n1094 DVDD.n1093 9.3005
R1764 DVDD.n1091 DVDD.n914 9.3005
R1765 DVDD.n1089 DVDD.n1088 9.3005
R1766 DVDD.n1087 DVDD.n915 9.3005
R1767 DVDD.n1086 DVDD.n1085 9.3005
R1768 DVDD.n1082 DVDD.n916 9.3005
R1769 DVDD.n1081 DVDD.n1080 9.3005
R1770 DVDD.n1079 DVDD.n1078 9.3005
R1771 DVDD.n1076 DVDD.n918 9.3005
R1772 DVDD.n1074 DVDD.n1073 9.3005
R1773 DVDD.n970 DVDD.n969 9.3005
R1774 DVDD.n972 DVDD.n966 9.3005
R1775 DVDD.n974 DVDD.n973 9.3005
R1776 DVDD.n977 DVDD.n976 9.3005
R1777 DVDD.n979 DVDD.n963 9.3005
R1778 DVDD.n982 DVDD.n981 9.3005
R1779 DVDD.n984 DVDD.n983 9.3005
R1780 DVDD.n985 DVDD.n960 9.3005
R1781 DVDD.n987 DVDD.n986 9.3005
R1782 DVDD.n989 DVDD.n988 9.3005
R1783 DVDD.n990 DVDD.n957 9.3005
R1784 DVDD.n992 DVDD.n991 9.3005
R1785 DVDD.n994 DVDD.n993 9.3005
R1786 DVDD.n996 DVDD.n955 9.3005
R1787 DVDD.n1000 DVDD.n999 9.3005
R1788 DVDD.n1001 DVDD.n954 9.3005
R1789 DVDD.n1003 DVDD.n1002 9.3005
R1790 DVDD.n1005 DVDD.n952 9.3005
R1791 DVDD.n1008 DVDD.n1007 9.3005
R1792 DVDD.n1010 DVDD.n1009 9.3005
R1793 DVDD.n1012 DVDD.n948 9.3005
R1794 DVDD.n1015 DVDD.n1014 9.3005
R1795 DVDD.n1017 DVDD.n1016 9.3005
R1796 DVDD.n1018 DVDD.n945 9.3005
R1797 DVDD.n1020 DVDD.n1019 9.3005
R1798 DVDD.n1021 DVDD.n944 9.3005
R1799 DVDD.n1023 DVDD.n1022 9.3005
R1800 DVDD.n1025 DVDD.n938 9.3005
R1801 DVDD.n1027 DVDD.n1026 9.3005
R1802 DVDD.n1028 DVDD.n937 9.3005
R1803 DVDD.n1030 DVDD.n1029 9.3005
R1804 DVDD.n1032 DVDD.n935 9.3005
R1805 DVDD.n1034 DVDD.n1033 9.3005
R1806 DVDD.n1036 DVDD.n1035 9.3005
R1807 DVDD.n1037 DVDD.n932 9.3005
R1808 DVDD.n1038 DVDD.n931 9.3005
R1809 DVDD.n1041 DVDD.n1040 9.3005
R1810 DVDD.n1042 DVDD.n930 9.3005
R1811 DVDD.n1044 DVDD.n1043 9.3005
R1812 DVDD.n1047 DVDD.n927 9.3005
R1813 DVDD.n1049 DVDD.n1048 9.3005
R1814 DVDD.n1051 DVDD.n1050 9.3005
R1815 DVDD.n1052 DVDD.n925 9.3005
R1816 DVDD.n1057 DVDD.n1056 9.3005
R1817 DVDD.n1058 DVDD.n924 9.3005
R1818 DVDD.n1060 DVDD.n1059 9.3005
R1819 DVDD.n1062 DVDD.n922 9.3005
R1820 DVDD.n1065 DVDD.n1064 9.3005
R1821 DVDD.n1066 DVDD.n921 9.3005
R1822 DVDD.n1068 DVDD.n1067 9.3005
R1823 DVDD.n1069 DVDD.n920 9.3005
R1824 DVDD.n1071 DVDD.n1070 9.3005
R1825 DVDD.n1072 DVDD.n919 9.3005
R1826 DVDD.n742 DVDD.n741 9.3005
R1827 DVDD.n743 DVDD.n738 9.3005
R1828 DVDD.n745 DVDD.n744 9.3005
R1829 DVDD.n748 DVDD.n747 9.3005
R1830 DVDD.n749 DVDD.n736 9.3005
R1831 DVDD.n751 DVDD.n750 9.3005
R1832 DVDD.n753 DVDD.n733 9.3005
R1833 DVDD.n756 DVDD.n755 9.3005
R1834 DVDD.n757 DVDD.n731 9.3005
R1835 DVDD.n839 DVDD.n838 9.3005
R1836 DVDD.n837 DVDD.n732 9.3005
R1837 DVDD.n836 DVDD.n835 9.3005
R1838 DVDD.n834 DVDD.n758 9.3005
R1839 DVDD.n832 DVDD.n831 9.3005
R1840 DVDD.n830 DVDD.n760 9.3005
R1841 DVDD.n829 DVDD.n828 9.3005
R1842 DVDD.n827 DVDD.n761 9.3005
R1843 DVDD.n825 DVDD.n824 9.3005
R1844 DVDD.n823 DVDD.n822 9.3005
R1845 DVDD.n820 DVDD.n763 9.3005
R1846 DVDD.n817 DVDD.n816 9.3005
R1847 DVDD.n815 DVDD.n765 9.3005
R1848 DVDD.n814 DVDD.n813 9.3005
R1849 DVDD.n812 DVDD.n766 9.3005
R1850 DVDD.n810 DVDD.n809 9.3005
R1851 DVDD.n808 DVDD.n767 9.3005
R1852 DVDD.n807 DVDD.n806 9.3005
R1853 DVDD.n803 DVDD.n768 9.3005
R1854 DVDD.n801 DVDD.n800 9.3005
R1855 DVDD.n799 DVDD.n769 9.3005
R1856 DVDD.n798 DVDD.n797 9.3005
R1857 DVDD.n796 DVDD.n770 9.3005
R1858 DVDD.n794 DVDD.n793 9.3005
R1859 DVDD.n792 DVDD.n778 9.3005
R1860 DVDD.n791 DVDD.n790 9.3005
R1861 DVDD.n789 DVDD.n779 9.3005
R1862 DVDD.n788 DVDD.n787 9.3005
R1863 DVDD.n730 DVDD.n729 9.3005
R1864 DVDD.n845 DVDD.n844 9.3005
R1865 DVDD.n846 DVDD.n728 9.3005
R1866 DVDD.n848 DVDD.n847 9.3005
R1867 DVDD.n851 DVDD.n726 9.3005
R1868 DVDD.n853 DVDD.n852 9.3005
R1869 DVDD.n855 DVDD.n854 9.3005
R1870 DVDD.n856 DVDD.n724 9.3005
R1871 DVDD.n860 DVDD.n859 9.3005
R1872 DVDD.n861 DVDD.n723 9.3005
R1873 DVDD.n863 DVDD.n862 9.3005
R1874 DVDD.n865 DVDD.n721 9.3005
R1875 DVDD.n870 DVDD.n869 9.3005
R1876 DVDD.n871 DVDD.n720 9.3005
R1877 DVDD.n873 DVDD.n872 9.3005
R1878 DVDD.n874 DVDD.n719 9.3005
R1879 DVDD.n876 DVDD.n875 9.3005
R1880 DVDD.n878 DVDD.n877 9.3005
R1881 DVDD.n879 DVDD.n717 9.3005
R1882 DVDD.n881 DVDD.n880 9.3005
R1883 DVDD.n882 DVDD.n716 9.3005
R1884 DVDD.n884 DVDD.n883 9.3005
R1885 DVDD.n886 DVDD.n714 9.3005
R1886 DVDD.n892 DVDD.n891 9.3005
R1887 DVDD.n893 DVDD.n713 9.3005
R1888 DVDD.n895 DVDD.n894 9.3005
R1889 DVDD.n897 DVDD.n712 9.3005
R1890 DVDD.n901 DVDD.n900 9.3005
R1891 DVDD.n902 DVDD.n711 9.3005
R1892 DVDD.n904 DVDD.n903 9.3005
R1893 DVDD.n905 DVDD.n710 9.3005
R1894 DVDD.n245 DVDD.n178 9.03579
R1895 DVDD.n219 DVDD.n218 9.03579
R1896 DVDD.n359 DVDD.n159 9.03579
R1897 DVDD.n465 DVDD.n464 9.03579
R1898 DVDD.n506 DVDD.n505 9.03579
R1899 DVDD.n509 DVDD.n508 9.03579
R1900 DVDD.n629 DVDD.n628 9.03579
R1901 DVDD.n675 DVDD.n674 9.03579
R1902 DVDD.n1148 DVDD.n1147 9.03579
R1903 DVDD.n1132 DVDD.n116 9.03579
R1904 DVDD.n1040 DVDD.n1039 9.03579
R1905 DVDD.n986 DVDD.n959 9.03579
R1906 DVDD.n1063 DVDD.n1062 9.03579
R1907 DVDD.n1077 DVDD.n917 9.03579
R1908 DVDD.n785 DVDD.n778 9.03579
R1909 DVDD.n812 DVDD.n811 9.03579
R1910 DVDD.n866 DVDD.n865 9.03579
R1911 DVDD.n875 DVDD.n718 9.03579
R1912 DVDD.n475 DVDD.n145 8.65932
R1913 DVDD.n599 DVDD.n548 8.65932
R1914 DVDD.n86 DVDD.n20 8.65932
R1915 DVDD.n806 DVDD.n804 8.65932
R1916 DVDD.n223 DVDD.n192 8.28285
R1917 DVDD.n169 DVDD.n168 8.28285
R1918 DVDD.n345 DVDD.n163 8.28285
R1919 DVDD.n578 DVDD.n555 8.28285
R1920 DVDD.n45 DVDD.n44 8.28285
R1921 DVDD.n970 DVDD.n967 8.28285
R1922 DVDD.n804 DVDD.n803 8.28285
R1923 DVDD.n741 DVDD.n740 8.28285
R1924 DVDD.n786 DVDD.n730 8.28285
R1925 DVDD.n450 DVDD.n449 7.52991
R1926 DVDD.n479 DVDD.n145 7.52991
R1927 DVDD.n603 DVDD.n548 7.52991
R1928 DVDD.n572 DVDD.n557 7.52991
R1929 DVDD.n668 DVDD.n667 7.52991
R1930 DVDD.n669 DVDD.n668 7.52991
R1931 DVDD.n90 DVDD.n20 7.52991
R1932 DVDD.n1155 DVDD.n1154 7.52991
R1933 DVDD.n1154 DVDD.n1153 7.52991
R1934 DVDD.n994 DVDD.n956 7.52991
R1935 DVDD.n1081 DVDD.n917 7.52991
R1936 DVDD.n851 DVDD.n850 7.52991
R1937 DVDD.n283 DVDD.n130 7.1731
R1938 DVDD.n244 DVDD.n243 7.15344
R1939 DVDD.n212 DVDD.n211 7.15344
R1940 DVDD.n272 DVDD.n269 7.15344
R1941 DVDD.n378 DVDD.n375 7.15344
R1942 DVDD.n354 DVDD.n352 7.15344
R1943 DVDD.n457 DVDD.n455 7.15344
R1944 DVDD.n501 DVDD.n500 7.15344
R1945 DVDD.n624 DVDD.n623 7.15344
R1946 DVDD.n655 DVDD.n654 7.15344
R1947 DVDD.n80 DVDD.n79 7.15344
R1948 DVDD.n38 DVDD.n10 7.15344
R1949 DVDD.n1033 DVDD.n934 7.15344
R1950 DVDD.n1054 DVDD.n1052 7.15344
R1951 DVDD.n1084 DVDD.n1082 7.15344
R1952 DVDD.n1092 DVDD.n1091 7.15344
R1953 DVDD.n1099 DVDD.n1097 7.15344
R1954 DVDD.n772 DVDD.n769 7.15344
R1955 DVDD.n820 DVDD.n819 7.15344
R1956 DVDD.n858 DVDD.n856 7.15344
R1957 DVDD.n869 DVDD.n868 7.15344
R1958 DVDD.n900 DVDD.n899 7.15344
R1959 DVDD.n562 DVDD.n561 6.81219
R1960 DVDD.n248 DVDD.n178 6.77697
R1961 DVDD.n220 DVDD.n219 6.77697
R1962 DVDD.n316 DVDD.n260 6.77697
R1963 DVDD.n423 DVDD.n368 6.77697
R1964 DVDD.n434 DVDD.n359 6.77697
R1965 DVDD.n469 DVDD.n465 6.77697
R1966 DVDD.n507 DVDD.n506 6.77697
R1967 DVDD.n634 DVDD.n538 6.77697
R1968 DVDD.n630 DVDD.n629 6.77697
R1969 DVDD.n582 DVDD.n581 6.77697
R1970 DVDD.n678 DVDD.n675 6.77697
R1971 DVDD.n60 DVDD.n27 6.77697
R1972 DVDD.n1147 DVDD.n1146 6.77697
R1973 DVDD.n1129 DVDD.n116 6.77697
R1974 DVDD.n978 DVDD.n977 6.77697
R1975 DVDD.n946 DVDD.n944 6.77697
R1976 DVDD.n995 DVDD.n994 6.77697
R1977 DVDD.n989 DVDD.n959 6.77697
R1978 DVDD.n1039 DVDD.n930 6.77697
R1979 DVDD.n1046 DVDD.n1045 6.77697
R1980 DVDD.n1056 DVDD.n1055 6.77697
R1981 DVDD.n1064 DVDD.n1063 6.77697
R1982 DVDD.n1093 DVDD.n1092 6.77697
R1983 DVDD.n1100 DVDD.n911 6.77697
R1984 DVDD.n790 DVDD.n785 6.77697
R1985 DVDD.n811 DVDD.n810 6.77697
R1986 DVDD.n747 DVDD.n746 6.77697
R1987 DVDD.n869 DVDD.n866 6.77697
R1988 DVDD.n878 DVDD.n718 6.77697
R1989 DVDD.n880 DVDD.n716 6.77697
R1990 DVDD.t245 DVDD.t448 6.71428
R1991 DVDD.t743 DVDD.t672 6.71428
R1992 DVDD.t878 DVDD.t711 6.71428
R1993 DVDD.t2 DVDD.t154 6.71428
R1994 DVDD.n258 DVDD.n257 6.4005
R1995 DVDD.n431 DVDD.n430 6.4005
R1996 DVDD.n637 DVDD.n636 6.4005
R1997 DVDD.n33 DVDD.n32 6.4005
R1998 DVDD.n5 DVDD.n4 6.27746
R1999 DVDD.n225 DVDD.n224 6.02403
R2000 DVDD.n392 DVDD.n391 6.02403
R2001 DVDD.n490 DVDD.n489 6.02403
R2002 DVDD.n613 DVDD.n612 6.02403
R2003 DVDD.n1068 DVDD.n921 6.02403
R2004 DVDD.n512 DVDD.n130 5.94779
R2005 DVDD.n1108 DVDD.n908 5.91717
R2006 DVDD.n342 DVDD.n341 5.91717
R2007 DVDD.n737 DVDD.n1 5.91717
R2008 DVDD.n239 DVDD.n181 5.64756
R2009 DVDD.n233 DVDD.n185 5.64756
R2010 DVDD.n207 DVDD.n206 5.64756
R2011 DVDD.n315 DVDD.n314 5.64756
R2012 DVDD.n308 DVDD.n307 5.64756
R2013 DVDD.n412 DVDD.n411 5.64756
R2014 DVDD.n419 DVDD.n418 5.64756
R2015 DVDD.n348 DVDD.n161 5.64756
R2016 DVDD.n451 DVDD.n152 5.64756
R2017 DVDD.n463 DVDD.n462 5.64756
R2018 DVDD.n662 DVDD.n527 5.64756
R2019 DVDD.n76 DVDD.n75 5.64756
R2020 DVDD.n65 DVDD.n64 5.64756
R2021 DVDD.n1172 DVDD.n1171 5.64756
R2022 DVDD.n973 DVDD.n965 5.64756
R2023 DVDD.n1031 DVDD.n1030 5.64756
R2024 DVDD.n1007 DVDD.n951 5.64756
R2025 DVDD.n1048 DVDD.n926 5.64756
R2026 DVDD.n1093 DVDD.n913 5.64756
R2027 DVDD.n788 DVDD.n786 5.64756
R2028 DVDD.n803 DVDD.n802 5.64756
R2029 DVDD.n852 DVDD.n725 5.64756
R2030 DVDD.n864 DVDD.n863 5.64756
R2031 DVDD.n885 DVDD.n884 5.64756
R2032 DVDD.n896 DVDD.n895 5.64756
R2033 DVDD.n238 DVDD.n237 5.27109
R2034 DVDD.t737 DVDD.t396 5.03584
R2035 DVDD.t105 DVDD.t381 5.03584
R2036 DVDD.t526 DVDD.t281 5.03584
R2037 DVDD.n268 DVDD.n267 4.51815
R2038 DVDD.n374 DVDD.n371 4.51815
R2039 DVDD.n70 DVDD.n69 4.51815
R2040 DVDD.n890 DVDD.n889 4.51815
R2041 DVDD.n1108 DVDD.n1107 4.5005
R2042 DVDD.n1110 DVDD.n1109 4.5005
R2043 DVDD.n709 DVDD.n708 4.5005
R2044 DVDD.n512 DVDD.n511 4.5005
R2045 DVDD.n975 DVDD.n1 4.5005
R2046 DVDD.n1181 DVDD.n1180 4.5005
R2047 DVDD.n558 DVDD.n0 4.5005
R2048 DVDD.n343 DVDD.n342 4.5005
R2049 DVDD.n1107 DVDD.n1106 4.44369
R2050 DVDD.n908 DVDD.n907 4.44369
R2051 DVDD.n242 DVDD.n181 4.14168
R2052 DVDD.n236 DVDD.n185 4.14168
R2053 DVDD.n206 DVDD.n202 4.14168
R2054 DVDD.n314 DVDD.n313 4.14168
R2055 DVDD.n307 DVDD.n306 4.14168
R2056 DVDD.n411 DVDD.n410 4.14168
R2057 DVDD.n418 DVDD.n417 4.14168
R2058 DVDD.n351 DVDD.n161 4.14168
R2059 DVDD.n454 DVDD.n152 4.14168
R2060 DVDD.n464 DVDD.n463 4.14168
R2061 DVDD.n652 DVDD.n651 4.14168
R2062 DVDD.n665 DVDD.n527 4.14168
R2063 DVDD.n77 DVDD.n76 4.14168
R2064 DVDD.n66 DVDD.n65 4.14168
R2065 DVDD.n1171 DVDD.n1170 4.14168
R2066 DVDD.n977 DVDD.n965 4.14168
R2067 DVDD.n1032 DVDD.n1031 4.14168
R2068 DVDD.n1019 DVDD.n946 4.14168
R2069 DVDD.n1010 DVDD.n951 4.14168
R2070 DVDD.n1051 DVDD.n926 4.14168
R2071 DVDD.n1096 DVDD.n913 4.14168
R2072 DVDD.n802 DVDD.n801 4.14168
R2073 DVDD.n855 DVDD.n725 4.14168
R2074 DVDD.n865 DVDD.n864 4.14168
R2075 DVDD.n886 DVDD.n885 4.14168
R2076 DVDD.n897 DVDD.n896 4.14168
R2077 DVDD.n1011 DVDD.n1010 3.76521
R2078 DVDD.t149 DVDD.t285 3.35739
R2079 DVDD.n449 DVDD.n448 3.01226
R2080 DVDD.n850 DVDD.n849 3.01226
R2081 DVDD.n245 DVDD.n244 2.63579
R2082 DVDD.n239 DVDD.n238 2.63579
R2083 DVDD.n213 DVDD.n212 2.63579
R2084 DVDD.n302 DVDD.n272 2.63579
R2085 DVDD.n406 DVDD.n378 2.63579
R2086 DVDD.n355 DVDD.n354 2.63579
R2087 DVDD.n458 DVDD.n457 2.63579
R2088 DVDD.n500 DVDD.n138 2.63579
R2089 DVDD.n623 DVDD.n540 2.63579
R2090 DVDD.n654 DVDD.n529 2.63579
R2091 DVDD.n79 DVDD.n22 2.63579
R2092 DVDD.n39 DVDD.n38 2.63579
R2093 DVDD.n1036 DVDD.n934 2.63579
R2094 DVDD.n1056 DVDD.n1054 2.63579
R2095 DVDD.n1085 DVDD.n1084 2.63579
R2096 DVDD.n1100 DVDD.n1099 2.63579
R2097 DVDD.n797 DVDD.n772 2.63579
R2098 DVDD.n819 DVDD.n817 2.63579
R2099 DVDD.n859 DVDD.n858 2.63579
R2100 DVDD.n868 DVDD.n720 2.63579
R2101 DVDD.n899 DVDD.n711 2.63579
R2102 DVDD.n1110 DVDD.n129 2.11005
R2103 DVDD.t718 DVDD.t472 1.67895
R2104 DVDD.t269 DVDD.t103 1.67895
R2105 DVDD.t767 DVDD.t99 1.67895
R2106 DVDD.t137 DVDD.t302 1.67895
R2107 DVDD.t499 DVDD.t50 1.67895
R2108 DVDD.t394 DVDD.t906 1.67895
R2109 DVDD.n497 DVDD.n496 1.50638
R2110 DVDD.n620 DVDD.n619 1.50638
R2111 DVDD.n709 DVDD.n512 1.41717
R2112 DVDD.n1109 DVDD.n709 1.41717
R2113 DVDD.n1109 DVDD.n1108 1.41717
R2114 DVDD.n342 DVDD.n0 1.41717
R2115 DVDD.n1181 DVDD.n1 1.41717
R2116 DVDD.n323 DVDD.n258 1.12991
R2117 DVDD.n296 DVDD.n277 1.12991
R2118 DVDD.n430 DVDD.n429 1.12991
R2119 DVDD.n467 DVDD.n147 1.12991
R2120 DVDD.n636 DVDD.n536 1.12991
R2121 DVDD.n590 DVDD.n550 1.12991
R2122 DVDD.n586 DVDD.n552 1.12991
R2123 DVDD.n568 DVDD.n559 1.12991
R2124 DVDD.n681 DVDD.n522 1.12991
R2125 DVDD.n688 DVDD.n520 1.12991
R2126 DVDD.n1115 DVDD.n126 1.12991
R2127 DVDD.n1122 DVDD.n1121 1.12991
R2128 DVDD.n32 DVDD.n30 1.12991
R2129 DVDD.n50 DVDD.n35 1.12991
R2130 DVDD.n1162 DVDD.n97 1.12991
R2131 DVDD.n1140 DVDD.n112 1.12991
R2132 DVDD.n1014 DVDD.n947 1.12991
R2133 DVDD.n1006 DVDD.n1005 1.12991
R2134 DVDD.n651 DVDD.n650 0.753441
R2135 DVDD.n999 DVDD.n998 0.753441
R2136 DVDD.n981 DVDD.n962 0.753441
R2137 DVDD.n1061 DVDD.n1060 0.753441
R2138 DVDD.n1076 DVDD.n1074 0.753441
R2139 DVDD.n1105 DVDD.n1104 0.753441
R2140 DVDD.n822 DVDD.n821 0.753441
R2141 DVDD.n752 DVDD.n751 0.753441
R2142 DVDD DVDD.n0 0.708833
R2143 DVDD DVDD.n1181 0.708833
R2144 DVDD.n561 DVDD.n560 0.508286
R2145 DVDD.n4 DVDD.n2 0.416404
R2146 DVDD.n253 DVDD.n252 0.376971
R2147 DVDD.n275 DVDD.n273 0.376971
R2148 DVDD.n294 DVDD.n278 0.376971
R2149 DVDD.n381 DVDD.n379 0.376971
R2150 DVDD.n631 DVDD.n538 0.376971
R2151 DVDD.n593 DVDD.n592 0.376971
R2152 DVDD.n573 DVDD.n572 0.376971
R2153 DVDD.n685 DVDD.n684 0.376971
R2154 DVDD.n698 DVDD.n697 0.376971
R2155 DVDD.n128 DVDD.n127 0.376971
R2156 DVDD.n124 DVDD.n121 0.376971
R2157 DVDD.n1124 DVDD.n1123 0.376971
R2158 DVDD.n1159 DVDD.n98 0.376971
R2159 DVDD.n1137 DVDD.n114 0.376971
R2160 DVDD.n742 DVDD.n739 0.302432
R2161 DVDD.n167 DVDD.n165 0.302224
R2162 DVDD.n969 DVDD.n968 0.191383
R2163 DVDD.n344 DVDD.n164 0.19062
R2164 DVDD.n282 DVDD.n130 0.129692
R2165 DVDD.n340 DVDD.n166 0.120292
R2166 DVDD.n170 DVDD.n166 0.120292
R2167 DVDD.n335 DVDD.n170 0.120292
R2168 DVDD.n335 DVDD.n334 0.120292
R2169 DVDD.n334 DVDD.n333 0.120292
R2170 DVDD.n333 DVDD.n172 0.120292
R2171 DVDD.n203 DVDD.n172 0.120292
R2172 DVDD.n208 DVDD.n203 0.120292
R2173 DVDD.n209 DVDD.n208 0.120292
R2174 DVDD.n210 DVDD.n209 0.120292
R2175 DVDD.n210 DVDD.n200 0.120292
R2176 DVDD.n215 DVDD.n200 0.120292
R2177 DVDD.n216 DVDD.n215 0.120292
R2178 DVDD.n216 DVDD.n193 0.120292
R2179 DVDD.n221 DVDD.n193 0.120292
R2180 DVDD.n222 DVDD.n221 0.120292
R2181 DVDD.n222 DVDD.n191 0.120292
R2182 DVDD.n191 DVDD.n190 0.120292
R2183 DVDD.n190 DVDD.n189 0.120292
R2184 DVDD.n228 DVDD.n189 0.120292
R2185 DVDD.n229 DVDD.n228 0.120292
R2186 DVDD.n230 DVDD.n229 0.120292
R2187 DVDD.n230 DVDD.n186 0.120292
R2188 DVDD.n234 DVDD.n186 0.120292
R2189 DVDD.n235 DVDD.n234 0.120292
R2190 DVDD.n235 DVDD.n182 0.120292
R2191 DVDD.n240 DVDD.n182 0.120292
R2192 DVDD.n241 DVDD.n240 0.120292
R2193 DVDD.n241 DVDD.n179 0.120292
R2194 DVDD.n246 DVDD.n179 0.120292
R2195 DVDD.n247 DVDD.n246 0.120292
R2196 DVDD.n247 DVDD.n177 0.120292
R2197 DVDD.n177 DVDD.n176 0.120292
R2198 DVDD.n254 DVDD.n176 0.120292
R2199 DVDD.n255 DVDD.n254 0.120292
R2200 DVDD.n326 DVDD.n255 0.120292
R2201 DVDD.n326 DVDD.n325 0.120292
R2202 DVDD.n325 DVDD.n324 0.120292
R2203 DVDD.n324 DVDD.n256 0.120292
R2204 DVDD.n259 DVDD.n256 0.120292
R2205 DVDD.n319 DVDD.n259 0.120292
R2206 DVDD.n319 DVDD.n318 0.120292
R2207 DVDD.n318 DVDD.n317 0.120292
R2208 DVDD.n317 DVDD.n261 0.120292
R2209 DVDD.n312 DVDD.n261 0.120292
R2210 DVDD.n312 DVDD.n311 0.120292
R2211 DVDD.n311 DVDD.n310 0.120292
R2212 DVDD.n310 DVDD.n264 0.120292
R2213 DVDD.n305 DVDD.n264 0.120292
R2214 DVDD.n305 DVDD.n304 0.120292
R2215 DVDD.n304 DVDD.n303 0.120292
R2216 DVDD.n303 DVDD.n270 0.120292
R2217 DVDD.n299 DVDD.n270 0.120292
R2218 DVDD.n299 DVDD.n298 0.120292
R2219 DVDD.n298 DVDD.n297 0.120292
R2220 DVDD.n297 DVDD.n274 0.120292
R2221 DVDD.n293 DVDD.n274 0.120292
R2222 DVDD.n293 DVDD.n292 0.120292
R2223 DVDD.n292 DVDD.n279 0.120292
R2224 DVDD.n288 DVDD.n279 0.120292
R2225 DVDD.n288 DVDD.n287 0.120292
R2226 DVDD.n287 DVDD.n286 0.120292
R2227 DVDD.n286 DVDD.n282 0.120292
R2228 DVDD.n349 DVDD.n162 0.120292
R2229 DVDD.n350 DVDD.n349 0.120292
R2230 DVDD.n350 DVDD.n160 0.120292
R2231 DVDD.n356 DVDD.n160 0.120292
R2232 DVDD.n357 DVDD.n356 0.120292
R2233 DVDD.n437 DVDD.n357 0.120292
R2234 DVDD.n437 DVDD.n436 0.120292
R2235 DVDD.n436 DVDD.n435 0.120292
R2236 DVDD.n435 DVDD.n358 0.120292
R2237 DVDD.n428 DVDD.n358 0.120292
R2238 DVDD.n428 DVDD.n427 0.120292
R2239 DVDD.n427 DVDD.n426 0.120292
R2240 DVDD.n426 DVDD.n366 0.120292
R2241 DVDD.n422 DVDD.n366 0.120292
R2242 DVDD.n422 DVDD.n421 0.120292
R2243 DVDD.n421 DVDD.n420 0.120292
R2244 DVDD.n420 DVDD.n369 0.120292
R2245 DVDD.n415 DVDD.n369 0.120292
R2246 DVDD.n415 DVDD.n414 0.120292
R2247 DVDD.n414 DVDD.n372 0.120292
R2248 DVDD.n409 DVDD.n372 0.120292
R2249 DVDD.n409 DVDD.n408 0.120292
R2250 DVDD.n408 DVDD.n407 0.120292
R2251 DVDD.n407 DVDD.n376 0.120292
R2252 DVDD.n403 DVDD.n376 0.120292
R2253 DVDD.n403 DVDD.n402 0.120292
R2254 DVDD.n402 DVDD.n401 0.120292
R2255 DVDD.n401 DVDD.n380 0.120292
R2256 DVDD.n396 DVDD.n380 0.120292
R2257 DVDD.n396 DVDD.n395 0.120292
R2258 DVDD.n395 DVDD.n394 0.120292
R2259 DVDD.n394 DVDD.n389 0.120292
R2260 DVDD.n390 DVDD.n389 0.120292
R2261 DVDD.n390 DVDD.n156 0.120292
R2262 DVDD.n444 DVDD.n156 0.120292
R2263 DVDD.n445 DVDD.n444 0.120292
R2264 DVDD.n446 DVDD.n445 0.120292
R2265 DVDD.n446 DVDD.n153 0.120292
R2266 DVDD.n452 DVDD.n153 0.120292
R2267 DVDD.n453 DVDD.n452 0.120292
R2268 DVDD.n453 DVDD.n151 0.120292
R2269 DVDD.n459 DVDD.n151 0.120292
R2270 DVDD.n460 DVDD.n459 0.120292
R2271 DVDD.n461 DVDD.n460 0.120292
R2272 DVDD.n461 DVDD.n148 0.120292
R2273 DVDD.n470 DVDD.n148 0.120292
R2274 DVDD.n471 DVDD.n470 0.120292
R2275 DVDD.n472 DVDD.n471 0.120292
R2276 DVDD.n472 DVDD.n146 0.120292
R2277 DVDD.n477 DVDD.n146 0.120292
R2278 DVDD.n478 DVDD.n477 0.120292
R2279 DVDD.n478 DVDD.n144 0.120292
R2280 DVDD.n482 DVDD.n144 0.120292
R2281 DVDD.n483 DVDD.n482 0.120292
R2282 DVDD.n484 DVDD.n483 0.120292
R2283 DVDD.n484 DVDD.n142 0.120292
R2284 DVDD.n492 DVDD.n142 0.120292
R2285 DVDD.n493 DVDD.n492 0.120292
R2286 DVDD.n494 DVDD.n493 0.120292
R2287 DVDD.n494 DVDD.n139 0.120292
R2288 DVDD.n502 DVDD.n139 0.120292
R2289 DVDD.n503 DVDD.n502 0.120292
R2290 DVDD.n504 DVDD.n503 0.120292
R2291 DVDD.n504 DVDD.n131 0.120292
R2292 DVDD.n510 DVDD.n137 0.120292
R2293 DVDD.n566 DVDD.n560 0.120292
R2294 DVDD.n567 DVDD.n566 0.120292
R2295 DVDD.n571 DVDD.n570 0.120292
R2296 DVDD.n571 DVDD.n556 0.120292
R2297 DVDD.n576 DVDD.n556 0.120292
R2298 DVDD.n577 DVDD.n576 0.120292
R2299 DVDD.n577 DVDD.n553 0.120292
R2300 DVDD.n584 DVDD.n553 0.120292
R2301 DVDD.n585 DVDD.n584 0.120292
R2302 DVDD.n585 DVDD.n551 0.120292
R2303 DVDD.n594 DVDD.n551 0.120292
R2304 DVDD.n595 DVDD.n594 0.120292
R2305 DVDD.n596 DVDD.n595 0.120292
R2306 DVDD.n596 DVDD.n549 0.120292
R2307 DVDD.n601 DVDD.n549 0.120292
R2308 DVDD.n602 DVDD.n601 0.120292
R2309 DVDD.n602 DVDD.n547 0.120292
R2310 DVDD.n606 DVDD.n547 0.120292
R2311 DVDD.n607 DVDD.n606 0.120292
R2312 DVDD.n608 DVDD.n607 0.120292
R2313 DVDD.n608 DVDD.n544 0.120292
R2314 DVDD.n615 DVDD.n544 0.120292
R2315 DVDD.n616 DVDD.n615 0.120292
R2316 DVDD.n617 DVDD.n616 0.120292
R2317 DVDD.n617 DVDD.n541 0.120292
R2318 DVDD.n625 DVDD.n541 0.120292
R2319 DVDD.n626 DVDD.n625 0.120292
R2320 DVDD.n627 DVDD.n626 0.120292
R2321 DVDD.n627 DVDD.n539 0.120292
R2322 DVDD.n632 DVDD.n539 0.120292
R2323 DVDD.n633 DVDD.n632 0.120292
R2324 DVDD.n633 DVDD.n537 0.120292
R2325 DVDD.n639 DVDD.n537 0.120292
R2326 DVDD.n640 DVDD.n639 0.120292
R2327 DVDD.n641 DVDD.n640 0.120292
R2328 DVDD.n641 DVDD.n535 0.120292
R2329 DVDD.n535 DVDD.n533 0.120292
R2330 DVDD.n647 DVDD.n533 0.120292
R2331 DVDD.n648 DVDD.n647 0.120292
R2332 DVDD.n649 DVDD.n648 0.120292
R2333 DVDD.n649 DVDD.n530 0.120292
R2334 DVDD.n656 DVDD.n530 0.120292
R2335 DVDD.n657 DVDD.n656 0.120292
R2336 DVDD.n658 DVDD.n657 0.120292
R2337 DVDD.n658 DVDD.n528 0.120292
R2338 DVDD.n663 DVDD.n528 0.120292
R2339 DVDD.n664 DVDD.n663 0.120292
R2340 DVDD.n664 DVDD.n525 0.120292
R2341 DVDD.n670 DVDD.n525 0.120292
R2342 DVDD.n671 DVDD.n670 0.120292
R2343 DVDD.n672 DVDD.n671 0.120292
R2344 DVDD.n672 DVDD.n523 0.120292
R2345 DVDD.n679 DVDD.n523 0.120292
R2346 DVDD.n680 DVDD.n679 0.120292
R2347 DVDD.n680 DVDD.n521 0.120292
R2348 DVDD.n686 DVDD.n521 0.120292
R2349 DVDD.n687 DVDD.n686 0.120292
R2350 DVDD.n687 DVDD.n518 0.120292
R2351 DVDD.n692 DVDD.n518 0.120292
R2352 DVDD.n693 DVDD.n692 0.120292
R2353 DVDD.n694 DVDD.n693 0.120292
R2354 DVDD.n694 DVDD.n516 0.120292
R2355 DVDD.n700 DVDD.n516 0.120292
R2356 DVDD.n701 DVDD.n700 0.120292
R2357 DVDD.n702 DVDD.n701 0.120292
R2358 DVDD.n702 DVDD.n513 0.120292
R2359 DVDD.n1179 DVDD.n3 0.120292
R2360 DVDD.n1175 DVDD.n3 0.120292
R2361 DVDD.n1175 DVDD.n1174 0.120292
R2362 DVDD.n1174 DVDD.n1173 0.120292
R2363 DVDD.n1173 DVDD.n9 0.120292
R2364 DVDD.n40 DVDD.n9 0.120292
R2365 DVDD.n41 DVDD.n40 0.120292
R2366 DVDD.n42 DVDD.n41 0.120292
R2367 DVDD.n42 DVDD.n36 0.120292
R2368 DVDD.n48 DVDD.n36 0.120292
R2369 DVDD.n49 DVDD.n48 0.120292
R2370 DVDD.n49 DVDD.n34 0.120292
R2371 DVDD.n34 DVDD.n31 0.120292
R2372 DVDD.n54 DVDD.n31 0.120292
R2373 DVDD.n55 DVDD.n54 0.120292
R2374 DVDD.n56 DVDD.n55 0.120292
R2375 DVDD.n56 DVDD.n29 0.120292
R2376 DVDD.n29 DVDD.n28 0.120292
R2377 DVDD.n61 DVDD.n28 0.120292
R2378 DVDD.n62 DVDD.n61 0.120292
R2379 DVDD.n63 DVDD.n62 0.120292
R2380 DVDD.n63 DVDD.n25 0.120292
R2381 DVDD.n72 DVDD.n25 0.120292
R2382 DVDD.n73 DVDD.n72 0.120292
R2383 DVDD.n74 DVDD.n73 0.120292
R2384 DVDD.n74 DVDD.n23 0.120292
R2385 DVDD.n81 DVDD.n23 0.120292
R2386 DVDD.n82 DVDD.n81 0.120292
R2387 DVDD.n83 DVDD.n82 0.120292
R2388 DVDD.n83 DVDD.n21 0.120292
R2389 DVDD.n88 DVDD.n21 0.120292
R2390 DVDD.n89 DVDD.n88 0.120292
R2391 DVDD.n89 DVDD.n14 0.120292
R2392 DVDD.n94 DVDD.n14 0.120292
R2393 DVDD.n95 DVDD.n94 0.120292
R2394 DVDD.n1164 DVDD.n95 0.120292
R2395 DVDD.n1164 DVDD.n1163 0.120292
R2396 DVDD.n1163 DVDD.n96 0.120292
R2397 DVDD.n1158 DVDD.n96 0.120292
R2398 DVDD.n1158 DVDD.n1157 0.120292
R2399 DVDD.n1157 DVDD.n99 0.120292
R2400 DVDD.n1151 DVDD.n99 0.120292
R2401 DVDD.n1151 DVDD.n1150 0.120292
R2402 DVDD.n1150 DVDD.n1149 0.120292
R2403 DVDD.n1149 DVDD.n102 0.120292
R2404 DVDD.n103 DVDD.n102 0.120292
R2405 DVDD.n1142 DVDD.n103 0.120292
R2406 DVDD.n1142 DVDD.n1141 0.120292
R2407 DVDD.n1141 DVDD.n111 0.120292
R2408 DVDD.n1136 DVDD.n111 0.120292
R2409 DVDD.n1136 DVDD.n1135 0.120292
R2410 DVDD.n1135 DVDD.n115 0.120292
R2411 DVDD.n1131 DVDD.n115 0.120292
R2412 DVDD.n1131 DVDD.n1130 0.120292
R2413 DVDD.n1130 DVDD.n117 0.120292
R2414 DVDD.n1126 DVDD.n117 0.120292
R2415 DVDD.n1126 DVDD.n1125 0.120292
R2416 DVDD.n1125 DVDD.n120 0.120292
R2417 DVDD.n1118 DVDD.n120 0.120292
R2418 DVDD.n1118 DVDD.n1117 0.120292
R2419 DVDD.n1117 DVDD.n1116 0.120292
R2420 DVDD.n1116 DVDD.n122 0.120292
R2421 DVDD.n1112 DVDD.n122 0.120292
R2422 DVDD.n1112 DVDD.n1111 0.120292
R2423 DVDD.n969 DVDD.n966 0.120292
R2424 DVDD.n974 DVDD.n966 0.120292
R2425 DVDD.n976 DVDD.n963 0.120292
R2426 DVDD.n982 DVDD.n963 0.120292
R2427 DVDD.n983 DVDD.n982 0.120292
R2428 DVDD.n983 DVDD.n960 0.120292
R2429 DVDD.n987 DVDD.n960 0.120292
R2430 DVDD.n988 DVDD.n987 0.120292
R2431 DVDD.n988 DVDD.n957 0.120292
R2432 DVDD.n992 DVDD.n957 0.120292
R2433 DVDD.n993 DVDD.n992 0.120292
R2434 DVDD.n993 DVDD.n955 0.120292
R2435 DVDD.n1000 DVDD.n955 0.120292
R2436 DVDD.n1001 DVDD.n1000 0.120292
R2437 DVDD.n1002 DVDD.n1001 0.120292
R2438 DVDD.n1002 DVDD.n952 0.120292
R2439 DVDD.n1008 DVDD.n952 0.120292
R2440 DVDD.n1009 DVDD.n1008 0.120292
R2441 DVDD.n1009 DVDD.n948 0.120292
R2442 DVDD.n1015 DVDD.n948 0.120292
R2443 DVDD.n1016 DVDD.n1015 0.120292
R2444 DVDD.n1016 DVDD.n945 0.120292
R2445 DVDD.n1020 DVDD.n945 0.120292
R2446 DVDD.n1021 DVDD.n1020 0.120292
R2447 DVDD.n1022 DVDD.n1021 0.120292
R2448 DVDD.n1022 DVDD.n938 0.120292
R2449 DVDD.n1027 DVDD.n938 0.120292
R2450 DVDD.n1028 DVDD.n1027 0.120292
R2451 DVDD.n1029 DVDD.n1028 0.120292
R2452 DVDD.n1029 DVDD.n935 0.120292
R2453 DVDD.n1034 DVDD.n935 0.120292
R2454 DVDD.n1035 DVDD.n1034 0.120292
R2455 DVDD.n1035 DVDD.n932 0.120292
R2456 DVDD.n932 DVDD.n931 0.120292
R2457 DVDD.n1041 DVDD.n931 0.120292
R2458 DVDD.n1042 DVDD.n1041 0.120292
R2459 DVDD.n1043 DVDD.n1042 0.120292
R2460 DVDD.n1043 DVDD.n927 0.120292
R2461 DVDD.n1049 DVDD.n927 0.120292
R2462 DVDD.n1050 DVDD.n1049 0.120292
R2463 DVDD.n1050 DVDD.n925 0.120292
R2464 DVDD.n1057 DVDD.n925 0.120292
R2465 DVDD.n1058 DVDD.n1057 0.120292
R2466 DVDD.n1059 DVDD.n1058 0.120292
R2467 DVDD.n1059 DVDD.n922 0.120292
R2468 DVDD.n1065 DVDD.n922 0.120292
R2469 DVDD.n1066 DVDD.n1065 0.120292
R2470 DVDD.n1067 DVDD.n1066 0.120292
R2471 DVDD.n1067 DVDD.n920 0.120292
R2472 DVDD.n1071 DVDD.n920 0.120292
R2473 DVDD.n1072 DVDD.n1071 0.120292
R2474 DVDD.n1073 DVDD.n1072 0.120292
R2475 DVDD.n1073 DVDD.n918 0.120292
R2476 DVDD.n1079 DVDD.n918 0.120292
R2477 DVDD.n1080 DVDD.n1079 0.120292
R2478 DVDD.n1080 DVDD.n916 0.120292
R2479 DVDD.n1086 DVDD.n916 0.120292
R2480 DVDD.n1087 DVDD.n1086 0.120292
R2481 DVDD.n1088 DVDD.n1087 0.120292
R2482 DVDD.n1088 DVDD.n914 0.120292
R2483 DVDD.n1094 DVDD.n914 0.120292
R2484 DVDD.n1095 DVDD.n1094 0.120292
R2485 DVDD.n1095 DVDD.n912 0.120292
R2486 DVDD.n1101 DVDD.n912 0.120292
R2487 DVDD.n1102 DVDD.n1101 0.120292
R2488 DVDD.n1102 DVDD.n909 0.120292
R2489 DVDD.n743 DVDD.n742 0.120292
R2490 DVDD.n744 DVDD.n743 0.120292
R2491 DVDD.n749 DVDD.n748 0.120292
R2492 DVDD.n750 DVDD.n749 0.120292
R2493 DVDD.n750 DVDD.n733 0.120292
R2494 DVDD.n756 DVDD.n733 0.120292
R2495 DVDD.n757 DVDD.n756 0.120292
R2496 DVDD.n838 DVDD.n757 0.120292
R2497 DVDD.n838 DVDD.n837 0.120292
R2498 DVDD.n837 DVDD.n836 0.120292
R2499 DVDD.n836 DVDD.n758 0.120292
R2500 DVDD.n831 DVDD.n758 0.120292
R2501 DVDD.n831 DVDD.n830 0.120292
R2502 DVDD.n830 DVDD.n829 0.120292
R2503 DVDD.n829 DVDD.n761 0.120292
R2504 DVDD.n824 DVDD.n761 0.120292
R2505 DVDD.n824 DVDD.n823 0.120292
R2506 DVDD.n823 DVDD.n763 0.120292
R2507 DVDD.n816 DVDD.n763 0.120292
R2508 DVDD.n816 DVDD.n815 0.120292
R2509 DVDD.n815 DVDD.n814 0.120292
R2510 DVDD.n814 DVDD.n766 0.120292
R2511 DVDD.n809 DVDD.n766 0.120292
R2512 DVDD.n809 DVDD.n808 0.120292
R2513 DVDD.n808 DVDD.n807 0.120292
R2514 DVDD.n807 DVDD.n768 0.120292
R2515 DVDD.n800 DVDD.n768 0.120292
R2516 DVDD.n800 DVDD.n799 0.120292
R2517 DVDD.n799 DVDD.n798 0.120292
R2518 DVDD.n798 DVDD.n770 0.120292
R2519 DVDD.n793 DVDD.n770 0.120292
R2520 DVDD.n793 DVDD.n792 0.120292
R2521 DVDD.n792 DVDD.n791 0.120292
R2522 DVDD.n791 DVDD.n779 0.120292
R2523 DVDD.n787 DVDD.n779 0.120292
R2524 DVDD.n787 DVDD.n729 0.120292
R2525 DVDD.n845 DVDD.n729 0.120292
R2526 DVDD.n846 DVDD.n845 0.120292
R2527 DVDD.n847 DVDD.n846 0.120292
R2528 DVDD.n847 DVDD.n726 0.120292
R2529 DVDD.n853 DVDD.n726 0.120292
R2530 DVDD.n854 DVDD.n853 0.120292
R2531 DVDD.n854 DVDD.n724 0.120292
R2532 DVDD.n860 DVDD.n724 0.120292
R2533 DVDD.n861 DVDD.n860 0.120292
R2534 DVDD.n862 DVDD.n861 0.120292
R2535 DVDD.n862 DVDD.n721 0.120292
R2536 DVDD.n870 DVDD.n721 0.120292
R2537 DVDD.n871 DVDD.n870 0.120292
R2538 DVDD.n872 DVDD.n871 0.120292
R2539 DVDD.n872 DVDD.n719 0.120292
R2540 DVDD.n876 DVDD.n719 0.120292
R2541 DVDD.n877 DVDD.n876 0.120292
R2542 DVDD.n877 DVDD.n717 0.120292
R2543 DVDD.n881 DVDD.n717 0.120292
R2544 DVDD.n882 DVDD.n881 0.120292
R2545 DVDD.n883 DVDD.n882 0.120292
R2546 DVDD.n883 DVDD.n714 0.120292
R2547 DVDD.n892 DVDD.n714 0.120292
R2548 DVDD.n893 DVDD.n892 0.120292
R2549 DVDD.n894 DVDD.n893 0.120292
R2550 DVDD.n894 DVDD.n712 0.120292
R2551 DVDD.n901 DVDD.n712 0.120292
R2552 DVDD.n902 DVDD.n901 0.120292
R2553 DVDD.n903 DVDD.n902 0.120292
R2554 DVDD.n903 DVDD.n710 0.120292
R2555 DVDD.n341 DVDD.n340 0.107271
R2556 DVDD.n343 DVDD.n162 0.107271
R2557 DVDD.n570 DVDD.n558 0.107271
R2558 DVDD.n1180 DVDD.n1179 0.107271
R2559 DVDD.n976 DVDD.n975 0.107271
R2560 DVDD.n748 DVDD.n737 0.107271
R2561 DVDD.n511 DVDD.n510 0.0812292
R2562 DVDD.n708 DVDD.n707 0.0812292
R2563 DVDD.n511 DVDD.n131 0.0395625
R2564 DVDD.n708 DVDD.n513 0.0395625
R2565 DVDD.n1111 DVDD.n1110 0.0395625
R2566 DVDD.n1107 DVDD.n909 0.0395625
R2567 DVDD.n908 DVDD.n710 0.0395625
R2568 DVDD.n341 DVDD.n165 0.0135208
R2569 DVDD.n344 DVDD.n343 0.0135208
R2570 DVDD.n567 DVDD.n558 0.0135208
R2571 DVDD.n1180 DVDD.n2 0.0135208
R2572 DVDD.n975 DVDD.n974 0.0135208
R2573 DVDD.n744 DVDD.n737 0.0135208
R2574 a4.n1 a4.t11 230.155
R2575 a4.n0 a4.t5 230.155
R2576 a4.n3 a4.t7 230.155
R2577 a4.n5 a4.t8 230.155
R2578 a4.n7 a4.t9 230.155
R2579 a4.n9 a4.t10 230.155
R2580 a4.n1 a4.t6 157.856
R2581 a4.n0 a4.t0 157.856
R2582 a4.n3 a4.t1 157.856
R2583 a4.n5 a4.t2 157.856
R2584 a4.n7 a4.t3 157.856
R2585 a4.n9 a4.t4 157.856
R2586 a4 a4.n0 152
R2587 a4 a4.n3 152
R2588 a4 a4.n5 152
R2589 a4 a4.n7 152
R2590 a4 a4.n9 152
R2591 a4 a4.n1 152
R2592 a4 a4.n8 31.3526
R2593 a4.n4 a4 24.6041
R2594 a4.n6 a4 21.6333
R2595 a4.n8 a4 19.5904
R2596 a4.n2 a4 19.3012
R2597 a4.n2 a4 16.1804
R2598 a4.n4 a4.n2 3.76613
R2599 a4.n6 a4.n4 0.6444
R2600 a4.n8 a4.n6 0.500267
R2601 DGND.n216 DGND.n28 75734.9
R2602 DGND.n981 DGND.n980 75734.9
R2603 DGND.n361 DGND.t309 73221
R2604 DGND.n1093 DGND.t320 64621.5
R2605 DGND.n362 DGND.n361 62260
R2606 DGND.n362 DGND.n9 62260
R2607 DGND.n1094 DGND.n9 62260
R2608 DGND.n1094 DGND.n1093 62260
R2609 DGND.n495 DGND.n28 60741.5
R2610 DGND.n679 DGND.n495 60741.5
R2611 DGND.n788 DGND.n679 60741.5
R2612 DGND.n980 DGND.n788 60741.5
R2613 DGND.t43 DGND.n216 9769.11
R2614 DGND.t241 DGND.t104 7173.67
R2615 DGND.t322 DGND.t195 3664.81
R2616 DGND.t443 DGND.t594 3548.66
R2617 DGND.n495 DGND.t481 3514.94
R2618 DGND.t712 DGND.t43 3453.16
R2619 DGND.t624 DGND.t630 3388.51
R2620 DGND.t882 DGND.t803 3286.08
R2621 DGND.t33 DGND.n28 3228.35
R2622 DGND.n788 DGND.t29 3228.35
R2623 DGND.t803 DGND.t241 3074.43
R2624 DGND.n217 DGND.t381 2974.18
R2625 DGND.n981 DGND.t884 2974.18
R2626 DGND.t199 DGND.n1092 2974.18
R2627 DGND.n361 DGND.t307 2865.9
R2628 DGND.n679 DGND.t380 2832.18
R2629 DGND.t391 DGND.t708 2762.53
R2630 DGND.t37 DGND.t393 2762.53
R2631 DGND.t395 DGND.t772 2613.03
R2632 DGND.n1092 DGND.t104 2528.61
R2633 DGND.t630 DGND.t33 2326.44
R2634 DGND.t514 DGND.t82 2138.73
R2635 DGND.n217 DGND.t179 2116.46
R2636 DGND.t230 DGND.t233 2094.18
R2637 DGND.t450 DGND.t445 2094.18
R2638 DGND.t201 DGND.t203 2094.18
R2639 DGND.t544 DGND.t542 2094.18
R2640 DGND.t172 DGND.t170 2094.18
R2641 DGND.t101 DGND.t274 2090.42
R2642 DGND.t516 DGND.t395 2014.56
R2643 DGND.t351 DGND.t774 1997.7
R2644 DGND.t125 DGND.t704 1997.7
R2645 DGND.t166 DGND.t301 1837.55
R2646 DGND.n980 DGND.t260 1677.39
R2647 DGND.n979 DGND.t332 1668.97
R2648 DGND.t860 DGND.n362 1626.82
R2649 DGND.t210 DGND.t212 1584.67
R2650 DGND.t636 DGND.t633 1584.67
R2651 DGND.t682 DGND.t680 1584.67
R2652 DGND.t341 DGND.t540 1584.67
R2653 DGND.t107 DGND.t375 1584.67
R2654 DGND.t695 DGND.t697 1584.67
R2655 DGND.t134 DGND.t137 1584.67
R2656 DGND.t113 DGND.t74 1525.67
R2657 DGND.t876 DGND.t156 1525.67
R2658 DGND.t87 DGND.t225 1525.67
R2659 DGND.t57 DGND.t404 1416.09
R2660 DGND.n1093 DGND.t402 1348.66
R2661 DGND.t181 DGND.n9 1314.94
R2662 DGND.t722 DGND.n1094 1314.94
R2663 DGND.t503 DGND.t687 1298.08
R2664 DGND.t823 DGND.t370 1298.08
R2665 DGND.t452 DGND.t471 1298.08
R2666 DGND.t842 DGND.t240 1230.65
R2667 DGND.t334 DGND.t291 1230.65
R2668 DGND.t328 DGND.t477 1222.22
R2669 DGND.n216 DGND.n215 1215.53
R2670 DGND.n982 DGND.n981 1214.47
R2671 DGND.n979 DGND.n978 1205.3
R2672 DGND.n840 DGND.n839 1202
R2673 DGND.n1096 DGND.n1095 1202
R2674 DGND.n787 DGND.n786 1202
R2675 DGND.n620 DGND.n541 1202
R2676 DGND.n678 DGND.n677 1202
R2677 DGND.n442 DGND.n363 1202
R2678 DGND.n494 DGND.n493 1202
R2679 DGND.n360 DGND.n359 1202
R2680 DGND.n121 DGND.n120 1202
R2681 DGND.n218 DGND.n217 1202
R2682 DGND.n1092 DGND.n1091 1202
R2683 DGND.t458 DGND.t725 1129.5
R2684 DGND.t67 DGND.n787 1112.64
R2685 DGND.t232 DGND.t712 1069.37
R2686 DGND.t447 DGND.t736 1069.37
R2687 DGND.t381 DGND.t448 1069.37
R2688 DGND.t586 DGND.t253 1069.37
R2689 DGND.t884 DGND.t206 1069.37
R2690 DGND.t265 DGND.t431 1069.37
R2691 DGND.t549 DGND.t199 1069.37
R2692 DGND.t315 DGND.t430 1069.37
R2693 DGND.t174 DGND.t322 1069.37
R2694 DGND.t258 DGND.t314 1069.37
R2695 DGND.t399 DGND.t332 1062.07
R2696 DGND.t654 DGND.t501 1036.78
R2697 DGND.t708 DGND.t235 1002.53
R2698 DGND.t449 DGND.t37 1002.53
R2699 DGND.t205 DGND.t882 1002.53
R2700 DGND.t195 DGND.t548 1002.53
R2701 DGND.t320 DGND.t175 1002.53
R2702 DGND.t714 DGND.t447 991.393
R2703 DGND.t253 DGND.t39 991.393
R2704 DGND.t431 DGND.t880 991.393
R2705 DGND.t191 DGND.t315 991.393
R2706 DGND.t316 DGND.t258 991.393
R2707 DGND.t750 DGND.t714 935.697
R2708 DGND.t233 DGND.t750 935.697
R2709 DGND.t710 DGND.t230 935.697
R2710 DGND.t756 DGND.t710 935.697
R2711 DGND.t235 DGND.t756 935.697
R2712 DGND.t179 DGND.t391 935.697
R2713 DGND.t39 DGND.t572 935.697
R2714 DGND.t572 DGND.t450 935.697
R2715 DGND.t445 DGND.t383 935.697
R2716 DGND.t383 DGND.t567 935.697
R2717 DGND.t567 DGND.t449 935.697
R2718 DGND.t393 DGND.t514 935.697
R2719 DGND.t82 DGND.t309 935.697
R2720 DGND.t880 DGND.t262 935.697
R2721 DGND.t262 DGND.t201 935.697
R2722 DGND.t203 DGND.t878 935.697
R2723 DGND.t878 DGND.t259 935.697
R2724 DGND.t259 DGND.t205 935.697
R2725 DGND.t428 DGND.t191 935.697
R2726 DGND.t542 DGND.t428 935.697
R2727 DGND.t189 DGND.t544 935.697
R2728 DGND.t432 DGND.t189 935.697
R2729 DGND.t548 DGND.t432 935.697
R2730 DGND.t311 DGND.t316 935.697
R2731 DGND.t170 DGND.t311 935.697
R2732 DGND.t318 DGND.t172 935.697
R2733 DGND.t313 DGND.t318 935.697
R2734 DGND.t175 DGND.t313 935.697
R2735 DGND.t361 DGND.t0 834.484
R2736 DGND.t207 DGND.t624 809.196
R2737 DGND.t32 DGND.t754 809.196
R2738 DGND.t784 DGND.t653 809.196
R2739 DGND.t755 DGND.t364 809.196
R2740 DGND.t359 DGND.t505 809.196
R2741 DGND.t481 DGND.t112 809.196
R2742 DGND.t788 DGND.t838 809.196
R2743 DGND.t116 DGND.t524 809.196
R2744 DGND.t7 DGND.t21 809.196
R2745 DGND.t419 DGND.t79 809.196
R2746 DGND.t221 DGND.t724 809.196
R2747 DGND.t63 DGND.t176 809.196
R2748 DGND.t772 DGND.t367 809.196
R2749 DGND.t420 DGND.t69 809.196
R2750 DGND.t856 DGND.t2 809.196
R2751 DGND.t463 DGND.t154 809.196
R2752 DGND.t121 DGND.t693 809.196
R2753 DGND.t759 DGND.t468 809.196
R2754 DGND.t146 DGND.t551 809.196
R2755 DGND.t462 DGND.t12 809.196
R2756 DGND.t606 DGND.t888 809.196
R2757 DGND.t435 DGND.t216 809.196
R2758 DGND.t306 DGND.t529 809.196
R2759 DGND.t536 DGND.t467 809.196
R2760 DGND.t815 DGND.t841 809.196
R2761 DGND.t397 DGND.t257 809.196
R2762 DGND.t9 DGND.t614 809.196
R2763 DGND.t245 DGND.t745 809.196
R2764 DGND.t339 DGND.t324 809.196
R2765 DGND.t477 DGND.t526 809.196
R2766 DGND.t556 DGND.t284 809.196
R2767 DGND.t736 DGND.t232 802.025
R2768 DGND.t448 DGND.t586 802.025
R2769 DGND.t206 DGND.t265 802.025
R2770 DGND.t430 DGND.t549 802.025
R2771 DGND.t314 DGND.t174 802.025
R2772 DGND.t590 DGND.t351 775.48
R2773 DGND.t29 DGND.t166 775.48
R2774 DGND.t209 DGND.t626 758.621
R2775 DGND.t635 DGND.t497 758.621
R2776 DGND.t485 DGND.t115 758.621
R2777 DGND.t870 DGND.t246 758.621
R2778 DGND.t587 DGND.t61 758.621
R2779 DGND.t594 DGND.t4 758.621
R2780 DGND.t665 DGND.t702 758.621
R2781 DGND.t133 DGND.t644 758.621
R2782 DGND.t457 DGND.t604 758.621
R2783 DGND.t837 DGND.t811 758.621
R2784 DGND.t409 DGND.t220 758.621
R2785 DGND.t340 DGND.t328 758.621
R2786 DGND.t353 DGND.t523 750.192
R2787 DGND.t833 DGND.t422 750.192
R2788 DGND.t97 DGND.t229 750.192
R2789 DGND.t838 DGND.t483 750.192
R2790 DGND.t874 DGND.t116 750.192
R2791 DGND.t127 DGND.t848 750.192
R2792 DGND.t69 DGND.t776 750.192
R2793 DGND.t0 DGND.t365 750.192
R2794 DGND.t345 DGND.t136 750.192
R2795 DGND.t12 DGND.t648 750.192
R2796 DGND.t216 DGND.t608 750.192
R2797 DGND.t529 DGND.t602 750.192
R2798 DGND.t264 DGND.t817 750.192
R2799 DGND.t415 DGND.t336 750.192
R2800 DGND.t699 DGND.t326 750.192
R2801 DGND.t401 DGND.t55 750.192
R2802 DGND.t614 DGND.t763 716.476
R2803 DGND.t628 DGND.t737 708.047
R2804 DGND.t737 DGND.t210 708.047
R2805 DGND.t762 DGND.t209 708.047
R2806 DGND.t739 DGND.t654 708.047
R2807 DGND.t424 DGND.t636 708.047
R2808 DGND.t423 DGND.t635 708.047
R2809 DGND.t23 DGND.t353 708.047
R2810 DGND.t357 DGND.t503 708.047
R2811 DGND.t669 DGND.t833 708.047
R2812 DGND.t829 DGND.t823 708.047
R2813 DGND.t553 DGND.t97 708.047
R2814 DGND.t677 DGND.t575 708.047
R2815 DGND.t117 DGND.t487 708.047
R2816 DGND.t487 DGND.t791 708.047
R2817 DGND.t156 DGND.t41 708.047
R2818 DGND.t160 DGND.t684 708.047
R2819 DGND.t278 DGND.t140 708.047
R2820 DGND.t18 DGND.t278 708.047
R2821 DGND.t109 DGND.t101 708.047
R2822 DGND.t225 DGND.t100 708.047
R2823 DGND.t896 DGND.t513 708.047
R2824 DGND.t89 DGND.t77 708.047
R2825 DGND.t77 DGND.t49 708.047
R2826 DGND.t540 DGND.t223 708.047
R2827 DGND.t848 DGND.t718 708.047
R2828 DGND.t718 DGND.t268 708.047
R2829 DGND.t766 DGND.t587 708.047
R2830 DGND.t380 DGND.t516 708.047
R2831 DGND.t365 DGND.t417 708.047
R2832 DGND.t770 DGND.t361 708.047
R2833 DGND.t421 DGND.t770 708.047
R2834 DGND.t2 DGND.t129 708.047
R2835 DGND.t349 DGND.t856 708.047
R2836 DGND.t102 DGND.t727 708.047
R2837 DGND.t437 DGND.t152 708.047
R2838 DGND.t152 DGND.t183 708.047
R2839 DGND.t697 DGND.t119 708.047
R2840 DGND.t119 DGND.t405 708.047
R2841 DGND.t642 DGND.t162 708.047
R2842 DGND.t746 DGND.t666 708.047
R2843 DGND.t155 DGND.t799 708.047
R2844 DGND.t662 DGND.t700 708.047
R2845 DGND.t106 DGND.t181 708.047
R2846 DGND.t70 DGND.t299 708.047
R2847 DGND.t299 DGND.t658 708.047
R2848 DGND.t658 DGND.t73 708.047
R2849 DGND.t148 DGND.t795 708.047
R2850 DGND.t392 DGND.t368 708.047
R2851 DGND.t797 DGND.t868 708.047
R2852 DGND.t868 DGND.t147 708.047
R2853 DGND.t648 DGND.t464 708.047
R2854 DGND.t464 DGND.t134 708.047
R2855 DGND.t137 DGND.t650 708.047
R2856 DGND.t650 DGND.t461 708.047
R2857 DGND.t461 DGND.t133 708.047
R2858 DGND.t433 DGND.t890 708.047
R2859 DGND.t640 DGND.t372 708.047
R2860 DGND.t886 DGND.t612 708.047
R2861 DGND.t612 DGND.t436 708.047
R2862 DGND.t598 DGND.t305 708.047
R2863 DGND.t305 DGND.t457 708.047
R2864 DGND.t538 DGND.t558 708.047
R2865 DGND.t582 DGND.t466 708.047
R2866 DGND.t817 DGND.t387 708.047
R2867 DGND.t193 DGND.t550 708.047
R2868 DGND.t390 DGND.t111 708.047
R2869 DGND.t763 DGND.t390 708.047
R2870 DGND.t13 DGND.t732 708.047
R2871 DGND.t563 DGND.t411 708.047
R2872 DGND.t220 DGND.t563 708.047
R2873 DGND.t326 DGND.t757 708.047
R2874 DGND.t565 DGND.t525 708.047
R2875 DGND.t51 DGND.t753 708.047
R2876 DGND.t753 DGND.t290 708.047
R2877 DGND.t404 DGND.t673 708.047
R2878 DGND.t675 DGND.t402 708.047
R2879 DGND.t347 DGND.t131 691.188
R2880 DGND.t493 DGND.t553 682.76
R2881 DGND.t748 DGND.t792 682.76
R2882 DGND.t596 DGND.t150 674.331
R2883 DGND.t14 DGND.t415 674.331
R2884 DGND.t620 DGND.t569 674.331
R2885 DGND.t732 DGND.t214 674.331
R2886 DGND.t55 DGND.t530 674.331
R2887 DGND.t734 DGND.t475 674.331
R2888 DGND.t286 DGND.t565 674.331
R2889 DGND.t257 DGND.t546 665.9
R2890 DGND.t249 DGND.t7 649.043
R2891 DGND.t616 DGND.t413 649.043
R2892 DGND.t10 DGND.t580 649.043
R2893 DGND.t53 DGND.t479 649.043
R2894 DGND.t744 DGND.t527 649.043
R2895 DGND.t854 DGND.t592 640.614
R2896 DGND.t743 DGND.t5 640.614
R2897 DGND.t858 DGND.t588 640.614
R2898 DGND.t158 DGND.t538 623.755
R2899 DGND.t385 DGND.t852 623.755
R2900 DGND.t290 DGND.t809 623.755
R2901 DGND.t252 DGND.t85 615.327
R2902 DGND.t767 DGND.t846 615.327
R2903 DGND.t408 DGND.t441 615.327
R2904 DGND.t280 DGND.t72 615.327
R2905 DGND.t754 DGND.t207 606.898
R2906 DGND.t653 DGND.t755 606.898
R2907 DGND.t505 DGND.t25 606.898
R2908 DGND.t112 DGND.t788 606.898
R2909 DGND.t524 DGND.t251 606.898
R2910 DGND.t872 DGND.t276 606.898
R2911 DGND.t520 DGND.t19 606.898
R2912 DGND.t246 DGND.t144 606.898
R2913 DGND.t79 DGND.t47 606.898
R2914 DGND.t367 DGND.t420 606.898
R2915 DGND.t733 DGND.t859 606.898
R2916 DGND.t128 DGND.t8 606.898
R2917 DGND.t154 DGND.t187 606.898
R2918 DGND.t664 DGND.t759 606.898
R2919 DGND.t72 DGND.t661 606.898
R2920 DGND.t793 DGND.t146 606.898
R2921 DGND.t888 DGND.t435 606.898
R2922 DGND.t467 DGND.t584 606.898
R2923 DGND.t841 DGND.t385 606.898
R2924 DGND.t745 DGND.t9 606.898
R2925 DGND.t768 DGND.t339 606.898
R2926 DGND.t526 DGND.t556 606.898
R2927 DGND.t523 DGND.n360 598.467
R2928 DGND.n839 DGND.t699 598.467
R2929 DGND.t521 DGND.t272 581.61
R2930 DGND.t236 DGND.t672 581.61
R2931 DGND.n120 DGND.t628 573.181
R2932 DGND.n363 DGND.t89 573.181
R2933 DGND.n541 DGND.t437 573.181
R2934 DGND.t686 DGND.t780 556.322
R2935 DGND.t518 DGND.t739 556.322
R2936 DGND.t42 DGND.t706 556.322
R2937 DGND.t892 DGND.t746 556.322
R2938 DGND.t394 DGND.t866 556.322
R2939 DGND.t177 DGND.t148 556.322
R2940 DGND.t618 DGND.t218 556.322
R2941 DGND.t288 DGND.t473 556.322
R2942 DGND.t501 DGND.t656 547.894
R2943 DGND.t426 DGND.t765 547.894
R2944 DGND.t760 DGND.t217 547.894
R2945 DGND.t285 DGND.t577 547.894
R2946 DGND.t41 DGND.t485 539.465
R2947 DGND.t702 DGND.t106 539.465
R2948 DGND.t460 DGND.t677 522.606
R2949 DGND.t255 DGND.t83 522.606
R2950 DGND.t741 DGND.t844 522.606
R2951 DGND.t406 DGND.t439 522.606
R2952 DGND.t799 DGND.t662 522.606
R2953 DGND.t164 DGND.t295 522.606
R2954 DGND.t168 DGND.t659 522.606
R2955 DGND.t27 DGND.t67 522.606
R2956 DGND.t368 DGND.t797 522.606
R2957 DGND.t372 DGND.t886 522.606
R2958 DGND.t466 DGND.t638 522.606
R2959 DGND.t811 DGND.n979 522.606
R2960 DGND.t724 DGND.t45 514.177
R2961 DGND.t389 DGND.t76 514.177
R2962 DGND.t176 DGND.t270 514.177
R2963 DGND.t679 DGND.t717 514.177
R2964 DGND.t693 DGND.t185 514.177
R2965 DGND.t294 DGND.t151 514.177
R2966 DGND.n678 DGND.t417 505.748
R2967 DGND.n1095 DGND.t433 505.748
R2968 DGND.t639 DGND.t789 488.889
R2969 DGND.t691 DGND.t113 488.889
R2970 DGND.t641 DGND.t303 488.889
R2971 DGND.t801 DGND.t458 488.889
R2972 DGND.t550 DGND.t399 488.889
R2973 DGND.t197 DGND.t35 488.889
R2974 DGND.t247 DGND.t143 480.461
R2975 DGND.t31 DGND.t26 480.461
R2976 DGND.t297 DGND.t793 480.461
R2977 DGND.t307 DGND.t93 472.031
R2978 DGND.t16 DGND.t48 472.031
R2979 DGND.t65 DGND.t266 472.031
R2980 DGND.t123 DGND.t188 472.031
R2981 DGND.n787 DGND.t70 472.031
R2982 DGND.t534 DGND.t722 472.031
R2983 DGND.t355 DGND.t671 463.603
R2984 DGND.t835 DGND.t561 463.603
R2985 DGND.t716 DGND.t80 463.603
R2986 DGND.t794 DGND.t132 463.603
R2987 DGND.t889 DGND.t454 463.603
R2988 DGND.t495 DGND.t786 455.173
R2989 DGND.t374 DGND.t18 455.173
R2990 DGND.t237 DGND.t142 455.173
R2991 DGND.t344 DGND.t421 455.173
R2992 DGND.t689 DGND.t363 455.173
R2993 DGND.t405 DGND.t778 455.173
R2994 DGND.t694 DGND.t227 455.173
R2995 DGND.t725 DGND.t455 455.173
R2996 DGND.t489 DGND.t598 455.173
R2997 DGND.t626 DGND.t784 446.743
R2998 DGND.t632 DGND.t782 446.743
R2999 DGND.t208 DGND.t652 446.743
R3000 DGND.t497 DGND.t359 446.743
R3001 DGND.t644 DGND.t606 446.743
R3002 DGND.t604 DGND.t536 446.743
R3003 DGND.t324 DGND.t409 446.743
R3004 DGND.t791 DGND.n494 438.315
R3005 DGND.t73 DGND.t864 429.885
R3006 DGND.t507 DGND.t379 421.457
R3007 DGND.t820 DGND.t239 421.457
R3008 DGND.t643 DGND.t469 421.457
R3009 DGND.t22 DGND.t831 413.027
R3010 DGND.t668 DGND.t95 413.027
R3011 DGND.t850 DGND.t254 413.027
R3012 DGND.t822 DGND.t22 396.17
R3013 DGND.t678 DGND.t668 396.17
R3014 DGND.t254 DGND.t267 396.17
R3015 DGND.t99 DGND.t622 387.74
R3016 DGND.t898 DGND.t762 387.74
R3017 DGND.t685 DGND.t499 387.74
R3018 DGND.t491 DGND.t423 387.74
R3019 DGND.t91 DGND.t728 387.74
R3020 DGND.t575 DGND.t825 387.74
R3021 DGND.t427 DGND.t59 387.74
R3022 DGND.t894 DGND.t766 387.74
R3023 DGND.t700 DGND.t779 387.74
R3024 DGND.t769 DGND.t720 387.74
R3025 DGND.t726 DGND.t532 387.74
R3026 DGND.t377 DGND.t582 387.74
R3027 DGND.t387 DGND.t827 387.74
R3028 DGND.t546 DGND.t139 387.74
R3029 DGND.t757 DGND.t282 387.74
R3030 DGND.n731 DGND.t555 373.283
R3031 DGND.n737 DGND.t579 373.283
R3032 DGND.n534 DGND.t583 373.283
R3033 DGND.n305 DGND.t560 373.283
R3034 DGND.n101 DGND.t585 373.283
R3035 DGND.t147 DGND.t646 362.452
R3036 DGND.t436 DGND.t600 362.452
R3037 DGND.t673 DGND.t729 362.452
R3038 DGND.n730 DGND.n728 357.442
R3039 DGND.n736 DGND.n734 357.442
R3040 DGND.n533 DGND.n531 357.442
R3041 DGND.n304 DGND.n302 357.442
R3042 DGND.n100 DGND.n98 357.442
R3043 DGND.t666 DGND.t155 354.024
R3044 DGND.t795 DGND.t392 354.024
R3045 DGND.t890 DGND.t640 354.024
R3046 DGND.t240 DGND.t839 354.024
R3047 DGND.t839 DGND.t807 354.024
R3048 DGND.t807 DGND.t813 354.024
R3049 DGND.t813 DGND.t805 354.024
R3050 DGND.t805 DGND.t386 354.024
R3051 DGND.t386 DGND.t243 354.024
R3052 DGND.t243 DGND.t837 354.024
R3053 DGND.t291 DGND.t337 354.024
R3054 DGND.t337 DGND.t511 354.024
R3055 DGND.t511 DGND.t330 354.024
R3056 DGND.t330 DGND.t509 354.024
R3057 DGND.t509 DGND.t752 354.024
R3058 DGND.t752 DGND.t292 354.024
R3059 DGND.t292 DGND.t340 354.024
R3060 DGND.n729 DGND.t576 346.022
R3061 DGND.n735 DGND.t568 346.022
R3062 DGND.n532 DGND.t557 346.022
R3063 DGND.n303 DGND.t552 346.022
R3064 DGND.n99 DGND.t571 346.022
R3065 DGND.t422 DGND.t355 345.594
R3066 DGND.t229 DGND.t835 345.594
R3067 DGND.t80 DGND.t127 345.594
R3068 DGND.t646 DGND.t794 345.594
R3069 DGND.t600 DGND.t889 345.594
R3070 DGND.t729 DGND.t675 345.594
R3071 DGND.t661 DGND.t31 328.736
R3072 DGND.t864 DGND.t297 328.736
R3073 DGND.n728 DGND.t908 325.082
R3074 DGND.n734 DGND.t910 325.082
R3075 DGND.n531 DGND.t909 325.082
R3076 DGND.n302 DGND.t911 325.082
R3077 DGND.n98 DGND.t914 325.082
R3078 DGND.t212 DGND.t99 320.307
R3079 DGND.t622 DGND.t898 320.307
R3080 DGND.t633 DGND.t685 320.307
R3081 DGND.t499 DGND.t491 320.307
R3082 DGND.t728 DGND.t682 320.307
R3083 DGND.t825 DGND.t91 320.307
R3084 DGND.t375 DGND.t427 320.307
R3085 DGND.t59 DGND.t894 320.307
R3086 DGND.t779 DGND.t769 320.307
R3087 DGND.t720 DGND.t665 320.307
R3088 DGND.t471 DGND.t726 320.307
R3089 DGND.t532 DGND.t377 320.307
R3090 DGND.t827 DGND.t842 320.307
R3091 DGND.t139 DGND.t197 320.307
R3092 DGND.t282 DGND.t334 320.307
R3093 DGND.t506 DGND.t822 311.877
R3094 DGND.t819 DGND.t678 311.877
R3095 DGND.t267 DGND.t343 311.877
R3096 DGND.t862 DGND.t462 311.877
R3097 DGND.t610 DGND.t306 311.877
R3098 DGND.t652 DGND.t495 303.449
R3099 DGND.t274 DGND.t237 303.449
R3100 DGND.t774 DGND.t689 303.449
R3101 DGND.t227 DGND.t125 303.449
R3102 DGND.t831 DGND.t357 295.019
R3103 DGND.t671 DGND.t506 295.019
R3104 DGND.t95 DGND.t829 295.019
R3105 DGND.t561 DGND.t819 295.019
R3106 DGND.t223 DGND.t850 295.019
R3107 DGND.t343 DGND.t716 295.019
R3108 DGND.t132 DGND.t862 295.019
R3109 DGND.t454 DGND.t610 295.019
R3110 DGND.t379 DGND.t23 286.591
R3111 DGND.t687 DGND.t507 286.591
R3112 DGND.t239 DGND.t669 286.591
R3113 DGND.t370 DGND.t820 286.591
R3114 DGND.t558 DGND.t643 286.591
R3115 DGND.t469 DGND.t452 286.591
R3116 DGND.t260 DGND.t815 286.591
R3117 DGND.n870 DGND.t403 283.065
R3118 DGND.n790 DGND.t244 278.589
R3119 DGND.n820 DGND.t547 278.589
R3120 DGND.n906 DGND.t293 278.589
R3121 DGND.n704 DGND.t28 275.293
R3122 DGND.n494 DGND.t115 269.733
R3123 DGND.n1047 DGND.t321 266.433
R3124 DGND.t656 DGND.t632 261.303
R3125 DGND.t765 DGND.t208 261.303
R3126 DGND.t49 DGND.t221 261.303
R3127 DGND.t268 DGND.t63 261.303
R3128 DGND.t183 DGND.t121 261.303
R3129 DGND.n19 DGND.t883 259.74
R3130 DGND.n978 DGND.t812 259.74
R3131 DGND.n835 DGND.t619 259.74
R3132 DGND.n863 DGND.t474 259.74
R3133 DGND.n865 DGND.t58 259.74
R3134 DGND.n711 DGND.t298 259.74
R3135 DGND.n723 DGND.t863 259.74
R3136 DGND.n1104 DGND.t611 259.74
R3137 DGND.n634 DGND.t348 259.74
R3138 DGND.n632 DGND.t595 259.74
R3139 DGND.n567 DGND.t703 259.74
R3140 DGND.n385 DGND.t62 259.74
R3141 DGND.n379 DGND.t81 259.74
R3142 DGND.n48 DGND.t486 259.74
R3143 DGND.n163 DGND.t787 259.74
R3144 DGND.n287 DGND.t356 259.74
R3145 DGND.n325 DGND.t836 259.74
R3146 DGND.n229 DGND.t38 259.74
R3147 DGND.n188 DGND.t709 259.74
R3148 DGND.n1066 DGND.t196 259.74
R3149 DGND.n925 DGND.t410 256.442
R3150 DGND.n850 DGND.t329 256.442
R3151 DGND.n5 DGND.t645 256.442
R3152 DGND.n1143 DGND.t605 256.442
R3153 DGND.n1123 DGND.t535 256.442
R3154 DGND.n660 DGND.t775 256.442
R3155 DGND.n604 DGND.t440 256.442
R3156 DGND.n592 DGND.t126 256.442
R3157 DGND.n396 DGND.t845 256.442
R3158 DGND.n465 DGND.t871 256.442
R3159 DGND.n456 DGND.t275 256.442
R3160 DGND.n426 DGND.t84 256.442
R3161 DGND.n138 DGND.t627 256.442
R3162 DGND.n274 DGND.t498 256.442
R3163 DGND.n307 DGND.t94 256.442
R3164 DGND.t786 DGND.t424 252.875
R3165 DGND.t142 DGND.t374 252.875
R3166 DGND.t363 DGND.t344 252.875
R3167 DGND.t778 DGND.t694 252.875
R3168 DGND.t455 DGND.t489 252.875
R3169 DGND.t150 DGND.t397 244.445
R3170 DGND.n33 DGND.t482 243.762
R3171 DGND.n992 DGND.t202 239.281
R3172 DGND.n804 DGND.t843 239.281
R3173 DGND.n828 DGND.t11 239.281
R3174 DGND.n832 DGND.t215 239.281
R3175 DGND.n845 DGND.t335 239.281
R3176 DGND.n856 DGND.t528 239.281
R3177 DGND.n860 DGND.t287 239.281
R3178 DGND.n769 DGND.t796 239.281
R3179 DGND.n726 DGND.t135 239.281
R3180 DGND.n1173 DGND.t891 239.281
R3181 DGND.n515 DGND.t366 239.281
R3182 DGND.n647 DGND.t855 239.281
R3183 DGND.n525 DGND.t3 239.281
R3184 DGND.n562 DGND.t667 239.281
R3185 DGND.n54 DGND.t248 239.281
R3186 DGND.n60 DGND.t145 239.281
R3187 DGND.n127 DGND.t211 239.281
R3188 DGND.n76 DGND.t637 239.281
R3189 DGND.n319 DGND.t681 239.281
R3190 DGND.n246 DGND.t451 239.281
R3191 DGND.n199 DGND.t234 239.281
R3192 DGND.n1034 DGND.t543 239.281
R3193 DGND.n1044 DGND.t171 239.281
R3194 DGND.n27 DGND.t885 237.536
R3195 DGND.n798 DGND.t816 237.536
R3196 DGND.n825 DGND.t414 237.536
R3197 DGND.n853 DGND.t54 237.536
R3198 DGND.n780 DGND.t865 237.536
R3199 DGND.n762 DGND.t647 237.536
R3200 DGND.n1166 DGND.t601 237.536
R3201 DGND.n500 DGND.t773 237.536
R3202 DGND.n519 DGND.t352 237.536
R3203 DGND.n655 DGND.t591 237.536
R3204 DGND.n626 DGND.t444 237.536
R3205 DGND.n590 DGND.t705 237.536
R3206 DGND.n486 DGND.t877 237.536
R3207 DGND.n480 DGND.t273 237.536
R3208 DGND.n448 DGND.t88 237.536
R3209 DGND.n114 DGND.t625 237.536
R3210 DGND.n180 DGND.t713 237.536
R3211 DGND.n257 DGND.t382 237.536
R3212 DGND.n1086 DGND.t200 237.536
R3213 DGND.n1061 DGND.t323 237.536
R3214 DGND.n953 DGND.t615 237.487
R3215 DGND.t93 DGND.t460 236.016
R3216 DGND.t76 DGND.t16 236.016
R3217 DGND.t48 DGND.t255 236.016
R3218 DGND.t717 DGND.t65 236.016
R3219 DGND.t266 DGND.t741 236.016
R3220 DGND.t151 DGND.t123 236.016
R3221 DGND.t188 DGND.t406 236.016
R3222 DGND.t638 DGND.t534 236.016
R3223 DGND.n1107 DGND.t459 235.984
R3224 DGND.n1116 DGND.t470 235.984
R3225 DGND.n705 DGND.t68 235.984
R3226 DGND.n544 DGND.t184 235.984
R3227 DGND.n603 DGND.t696 235.984
R3228 DGND.n395 DGND.t108 235.984
R3229 DGND.n380 DGND.t269 235.984
R3230 DGND.n366 DGND.t50 235.984
R3231 DGND.n425 DGND.t342 235.984
R3232 DGND.n32 DGND.t114 235.984
R3233 DGND.n148 DGND.t655 235.984
R3234 DGND.n352 DGND.t508 235.984
R3235 DGND.n289 DGND.t821 235.984
R3236 DGND.n837 DGND.t325 234.238
R3237 DGND.n852 DGND.t478 234.238
R3238 DGND.n742 DGND.t607 234.238
R3239 DGND.n1145 DGND.t537 234.238
R3240 DGND.n688 DGND.t302 234.238
R3241 DGND.n617 DGND.t122 234.238
R3242 DGND.n411 DGND.t64 234.238
R3243 DGND.n439 DGND.t222 234.238
R3244 DGND.n376 DGND.t851 234.238
R3245 DGND.n85 DGND.t785 234.238
R3246 DGND.n80 DGND.t502 234.238
R3247 DGND.n272 DGND.t360 234.238
R3248 DGND.n284 DGND.t832 234.238
R3249 DGND.n332 DGND.t96 234.238
R3250 DGND.t143 DGND.t521 227.587
R3251 DGND.t26 DGND.t164 227.587
R3252 DGND.t584 DGND.t236 227.587
R3253 DGND.t483 DGND.t639 219.157
R3254 DGND.t789 DGND.t691 219.157
R3255 DGND.t140 DGND.t870 219.157
R3256 DGND.t602 DGND.t641 219.157
R3257 DGND.t303 DGND.t801 219.157
R3258 DGND.t35 DGND.t193 219.157
R3259 DGND.n728 DGND.t564 215.829
R3260 DGND.n734 DGND.t562 215.829
R3261 DGND.n531 DGND.t581 215.829
R3262 DGND.n302 DGND.t574 215.829
R3263 DGND.n98 DGND.t566 215.829
R3264 DGND.n360 DGND.t25 210.728
R3265 DGND.n839 DGND.t768 210.728
R3266 DGND.t776 DGND.n678 202.299
R3267 DGND.n1095 DGND.t608 202.299
R3268 DGND.t218 DGND.t13 202.299
R3269 DGND.t525 DGND.t288 202.299
R3270 DGND.n964 DGND.n819 200.127
R3271 DGND.n958 DGND.n822 199.739
R3272 DGND.n995 DGND.n994 198.964
R3273 DGND.n24 DGND.n23 198.964
R3274 DGND.n946 DGND.n827 198.964
R3275 DGND.n941 DGND.n830 198.964
R3276 DGND.n940 DGND.n831 198.964
R3277 DGND.n934 DGND.n834 198.964
R3278 DGND.n895 DGND.n855 198.964
R3279 DGND.n890 DGND.n858 198.964
R3280 DGND.n889 DGND.n859 198.964
R3281 DGND.n883 DGND.n862 198.964
R3282 DGND.n682 DGND.n681 198.964
R3283 DGND.n755 DGND.n724 198.964
R3284 DGND.n748 DGND.n733 198.964
R3285 DGND.n1159 DGND.n1105 198.964
R3286 DGND.n1136 DGND.n1115 198.964
R3287 DGND.n1130 DGND.n1119 198.964
R3288 DGND.n668 DGND.n516 198.964
R3289 DGND.n649 DGND.n523 198.964
R3290 DGND.n648 DGND.n524 198.964
R3291 DGND.n642 DGND.n527 198.964
R3292 DGND.n640 DGND.n528 198.964
R3293 DGND.n618 DGND.n543 198.964
R3294 DGND.n611 DGND.n546 198.964
R3295 DGND.n606 DGND.n549 198.964
R3296 DGND.n553 DGND.n552 198.964
R3297 DGND.n388 DGND.n387 198.964
R3298 DGND.n399 DGND.n398 198.964
R3299 DGND.n405 DGND.n404 198.964
R3300 DGND.n413 DGND.n412 198.964
R3301 DGND.n479 DGND.n52 198.964
R3302 DGND.n440 DGND.n365 198.964
R3303 DGND.n433 DGND.n368 198.964
R3304 DGND.n428 DGND.n371 198.964
R3305 DGND.n35 DGND.n34 198.964
R3306 DGND.n43 DGND.n42 198.964
R3307 DGND.n91 DGND.n90 198.964
R3308 DGND.n88 DGND.n87 198.964
R3309 DGND.n155 DGND.n154 198.964
R3310 DGND.n162 DGND.n161 198.964
R3311 DGND.n170 DGND.n169 198.964
R3312 DGND.n354 DGND.n279 198.964
R3313 DGND.n339 DGND.n288 198.964
R3314 DGND.n296 DGND.n295 198.964
R3315 DGND.n299 DGND.n298 198.964
R3316 DGND.n225 DGND.n224 198.964
R3317 DGND.n222 DGND.n221 198.964
R3318 DGND.n187 DGND.n186 198.964
R3319 DGND.n202 DGND.n201 198.964
R3320 DGND.n1079 DGND.n1033 198.964
R3321 DGND.n1073 DGND.n1036 198.964
R3322 DGND.n1054 DGND.n1043 198.964
R3323 DGND.n1048 DGND.n1046 198.964
R3324 DGND.n812 DGND.n792 196.831
R3325 DGND.n848 DGND.n847 196.831
R3326 DGND.n868 DGND.n867 196.831
R3327 DGND.n701 DGND.n685 196.831
R3328 DGND.n810 DGND.n793 195.667
R3329 DGND.n802 DGND.n796 195.667
R3330 DGND.n918 DGND.n842 195.667
R3331 DGND.n911 DGND.n846 195.667
R3332 DGND.n714 DGND.n713 195.667
R3333 DGND.n764 DGND.n719 195.667
R3334 DGND.n1097 DGND.n8 195.667
R3335 DGND.n1168 DGND.n1100 195.667
R3336 DGND.n1152 DGND.n1109 195.667
R3337 DGND.n702 DGND.n684 195.667
R3338 DGND.n583 DGND.n559 195.667
R3339 DGND.n574 DGND.n563 195.667
R3340 DGND.n676 DGND.n497 195.667
R3341 DGND.n473 DGND.n56 195.667
R3342 DGND.n472 DGND.n57 195.667
R3343 DGND.n464 DGND.n61 195.667
R3344 DGND.n375 DGND.n374 195.667
R3345 DGND.n145 DGND.n82 195.667
R3346 DGND.n283 DGND.n282 195.667
R3347 DGND.n333 DGND.n292 195.667
R3348 DGND.t364 DGND.t686 193.87
R3349 DGND.t85 DGND.t389 193.87
R3350 DGND.t846 DGND.t679 193.87
R3351 DGND.t441 DGND.t294 193.87
R3352 DGND.t468 DGND.t42 193.87
R3353 DGND.t301 DGND.t280 193.87
R3354 DGND.t551 DGND.t394 193.87
R3355 DGND.n729 DGND.t904 193.337
R3356 DGND.n735 DGND.t906 193.337
R3357 DGND.n532 DGND.t901 193.337
R3358 DGND.n303 DGND.t903 193.337
R3359 DGND.n99 DGND.t912 193.337
R3360 DGND.t83 DGND.t341 185.441
R3361 DGND.t844 DGND.t107 185.441
R3362 DGND.t439 DGND.t695 185.441
R3363 DGND.t295 DGND.t168 185.441
R3364 DGND.t659 DGND.t27 185.441
R3365 DGND.t852 DGND.t264 185.441
R3366 DGND.n967 DGND.n966 185
R3367 DGND.n965 DGND.n817 185
R3368 DGND.n120 DGND.t32 177.012
R3369 DGND.n363 DGND.t419 177.012
R3370 DGND.n541 DGND.t463 177.012
R3371 DGND.t8 DGND.t733 168.583
R3372 DGND.n731 DGND.t913 167.63
R3373 DGND.n737 DGND.t902 167.63
R3374 DGND.n534 DGND.t907 167.63
R3375 DGND.n305 DGND.t900 167.63
R3376 DGND.n101 DGND.t905 167.63
R3377 DGND.n689 DGND.t30 161.968
R3378 DGND.t782 DGND.t426 160.154
R3379 DGND.t61 DGND.t860 160.154
R3380 DGND.t217 DGND.t616 160.154
R3381 DGND.t336 DGND.t10 160.154
R3382 DGND.t479 DGND.t285 160.154
R3383 DGND.t527 DGND.t401 160.154
R3384 DGND.n1026 DGND.t105 158.361
R3385 DGND.n1012 DGND.t242 158.361
R3386 DGND.n17 DGND.t804 158.361
R3387 DGND.n797 DGND.t853 158.361
R3388 DGND.n798 DGND.t261 158.361
R3389 DGND.n690 DGND.t167 158.361
R3390 DGND.n503 DGND.t396 158.361
R3391 DGND.n670 DGND.t1 158.361
R3392 DGND.n107 DGND.t731 158.361
R3393 DGND.n107 DGND.t631 158.361
R3394 DGND.n97 DGND.t34 158.361
R3395 DGND.n214 DGND.t44 158.361
R3396 DGND.n385 DGND.t861 156.928
R3397 DGND.n43 DGND.t75 156.928
R3398 DGND.n319 DGND.t494 156.928
R3399 DGND.n231 DGND.t310 156.911
R3400 DGND.n502 DGND.t517 156.577
R3401 DGND.n566 DGND.t182 156.034
R3402 DGND.n869 DGND.t730 153.631
R3403 DGND.n730 DGND.n729 152
R3404 DGND.n732 DGND.n731 152
R3405 DGND.n736 DGND.n735 152
R3406 DGND.n738 DGND.n737 152
R3407 DGND.n533 DGND.n532 152
R3408 DGND.n535 DGND.n534 152
R3409 DGND.n304 DGND.n303 152
R3410 DGND.n306 DGND.n305 152
R3411 DGND.n100 DGND.n99 152
R3412 DGND.n102 DGND.n101 152
R3413 DGND.t780 DGND.t518 151.725
R3414 DGND.t706 DGND.t892 151.725
R3415 DGND.t866 DGND.t177 151.725
R3416 DGND.t411 DGND.t618 151.725
R3417 DGND.t473 DGND.t51 151.725
R3418 DGND.n1137 DGND.t159 150.922
R3419 DGND.n1120 DGND.t378 150.922
R3420 DGND.n539 DGND.t103 150.922
R3421 DGND.n557 DGND.t163 150.922
R3422 DGND.n569 DGND.t721 150.922
R3423 DGND.n389 DGND.t895 150.922
R3424 DGND.n487 DGND.t157 150.922
R3425 DGND.n50 DGND.t161 150.922
R3426 DGND.n450 DGND.t110 150.922
R3427 DGND.n449 DGND.t226 150.922
R3428 DGND.n69 DGND.t897 150.922
R3429 DGND.n133 DGND.t899 150.922
R3430 DGND.n74 DGND.t492 150.922
R3431 DGND.n313 DGND.t826 150.922
R3432 DGND.n230 DGND.t515 150.922
R3433 DGND.n263 DGND.t180 150.922
R3434 DGND.n953 DGND.t764 149.493
R3435 DGND.n716 DGND.t178 147.411
R3436 DGND.n717 DGND.t369 147.411
R3437 DGND.n1098 DGND.t373 147.411
R3438 DGND.n1158 DGND.t802 147.411
R3439 DGND.n1151 DGND.t490 147.411
R3440 DGND.n1118 DGND.t453 147.411
R3441 DGND.n1122 DGND.t723 147.411
R3442 DGND.n662 DGND.t690 147.411
R3443 DGND.n554 DGND.t228 147.411
R3444 DGND.n582 DGND.t893 147.411
R3445 DGND.n576 DGND.t800 147.411
R3446 DGND.n458 DGND.t238 147.411
R3447 DGND.n36 DGND.t692 147.411
R3448 DGND.n146 DGND.t519 147.411
R3449 DGND.n351 DGND.t688 147.411
R3450 DGND.n291 DGND.t371 147.411
R3451 DGND.n308 DGND.t308 147.411
R3452 DGND.n973 DGND.t333 144.885
R3453 DGND.n878 DGND.t810 144.885
R3454 DGND.n803 DGND.t828 141.135
R3455 DGND.n694 DGND.t281 141.135
R3456 DGND.n917 DGND.t283 141.133
R3457 DGND.t111 DGND.t596 134.867
R3458 DGND.t809 DGND.t57 134.867
R3459 DGND.t272 DGND.t874 126.438
R3460 DGND.t21 DGND.t247 126.438
R3461 DGND.t672 DGND.t158 126.438
R3462 DGND.n750 DGND.n732 114.776
R3463 DGND.n536 DGND.n535 108.954
R3464 DGND.t276 DGND.t249 101.15
R3465 DGND.t19 DGND.t872 101.15
R3466 DGND.t144 DGND.t520 101.15
R3467 DGND.t413 DGND.t245 101.15
R3468 DGND.t284 DGND.t53 101.15
R3469 DGND.n966 DGND.n965 97.1434
R3470 DGND.t684 DGND.t876 92.7208
R3471 DGND.t513 DGND.t87 92.7208
R3472 DGND.t45 DGND.t252 92.7208
R3473 DGND.t270 DGND.t767 92.7208
R3474 DGND.t727 DGND.t443 92.7208
R3475 DGND.t185 DGND.t408 92.7208
R3476 DGND.t704 DGND.t642 92.7208
R3477 DGND.n732 DGND.n730 86.1712
R3478 DGND.n738 DGND.n736 86.1712
R3479 DGND.n535 DGND.n533 86.1712
R3480 DGND.n306 DGND.n304 86.1712
R3481 DGND.n102 DGND.n100 86.1712
R3482 DGND.n822 DGND.t398 74.2862
R3483 DGND.n739 DGND.n738 72.8693
R3484 DGND.t100 DGND.t109 67.4335
R3485 DGND.t592 DGND.t748 67.4335
R3486 DGND.t129 DGND.t854 67.4335
R3487 DGND.t5 DGND.t349 67.4335
R3488 DGND.t588 DGND.t743 67.4335
R3489 DGND.t131 DGND.t858 67.4335
R3490 DGND.n966 DGND.t36 61.4291
R3491 DGND.t74 DGND.t117 59.0043
R3492 DGND.t580 DGND.t760 59.0043
R3493 DGND.t577 DGND.t744 59.0043
R3494 DGND.n103 DGND.n102 40.6793
R3495 DGND.n994 DGND.t204 38.5719
R3496 DGND.n994 DGND.t879 38.5719
R3497 DGND.n23 DGND.t881 38.5719
R3498 DGND.n23 DGND.t263 38.5719
R3499 DGND.n793 DGND.t840 38.5719
R3500 DGND.n793 DGND.t814 38.5719
R3501 DGND.n796 DGND.t818 38.5719
R3502 DGND.n796 DGND.t388 38.5719
R3503 DGND.n965 DGND.t400 38.5719
R3504 DGND.n827 DGND.t617 38.5719
R3505 DGND.n827 DGND.t761 38.5719
R3506 DGND.n830 DGND.t416 38.5719
R3507 DGND.n830 DGND.t570 38.5719
R3508 DGND.n831 DGND.t15 38.5719
R3509 DGND.n831 DGND.t621 38.5719
R3510 DGND.n834 DGND.t219 38.5719
R3511 DGND.n834 DGND.t412 38.5719
R3512 DGND.n842 DGND.t327 38.5719
R3513 DGND.n842 DGND.t758 38.5719
R3514 DGND.n846 DGND.t338 38.5719
R3515 DGND.n846 DGND.t331 38.5719
R3516 DGND.n855 DGND.t480 38.5719
R3517 DGND.n855 DGND.t578 38.5719
R3518 DGND.n858 DGND.t56 38.5719
R3519 DGND.n858 DGND.t735 38.5719
R3520 DGND.n859 DGND.t531 38.5719
R3521 DGND.n859 DGND.t476 38.5719
R3522 DGND.n862 DGND.t289 38.5719
R3523 DGND.n862 DGND.t52 38.5719
R3524 DGND.n681 DGND.t71 38.5719
R3525 DGND.n681 DGND.t300 38.5719
R3526 DGND.n713 DGND.t867 38.5719
R3527 DGND.n713 DGND.t149 38.5719
R3528 DGND.n719 DGND.t798 38.5719
R3529 DGND.n719 DGND.t869 38.5719
R3530 DGND.n724 DGND.t649 38.5719
R3531 DGND.n724 DGND.t465 38.5719
R3532 DGND.n733 DGND.t138 38.5719
R3533 DGND.n733 DGND.t651 38.5719
R3534 DGND.n8 DGND.t609 38.5719
R3535 DGND.n8 DGND.t434 38.5719
R3536 DGND.n1100 DGND.t887 38.5719
R3537 DGND.n1100 DGND.t613 38.5719
R3538 DGND.n1105 DGND.t603 38.5719
R3539 DGND.n1105 DGND.t304 38.5719
R3540 DGND.n1109 DGND.t456 38.5719
R3541 DGND.n1109 DGND.t599 38.5719
R3542 DGND.n1115 DGND.t539 38.5719
R3543 DGND.n1115 DGND.t559 38.5719
R3544 DGND.n1119 DGND.t472 38.5719
R3545 DGND.n1119 DGND.t533 38.5719
R3546 DGND.n684 DGND.t296 38.5719
R3547 DGND.n684 DGND.t660 38.5719
R3548 DGND.n516 DGND.t362 38.5719
R3549 DGND.n516 DGND.t771 38.5719
R3550 DGND.n523 DGND.t346 38.5719
R3551 DGND.n523 DGND.t749 38.5719
R3552 DGND.n524 DGND.t593 38.5719
R3553 DGND.n524 DGND.t130 38.5719
R3554 DGND.n527 DGND.t857 38.5719
R3555 DGND.n527 DGND.t350 38.5719
R3556 DGND.n528 DGND.t6 38.5719
R3557 DGND.n528 DGND.t589 38.5719
R3558 DGND.n543 DGND.t438 38.5719
R3559 DGND.n543 DGND.t153 38.5719
R3560 DGND.n546 DGND.t186 38.5719
R3561 DGND.n546 DGND.t442 38.5719
R3562 DGND.n549 DGND.t124 38.5719
R3563 DGND.n549 DGND.t407 38.5719
R3564 DGND.n552 DGND.t698 38.5719
R3565 DGND.n552 DGND.t120 38.5719
R3566 DGND.n559 DGND.t707 38.5719
R3567 DGND.n559 DGND.t747 38.5719
R3568 DGND.n563 DGND.t663 38.5719
R3569 DGND.n563 DGND.t701 38.5719
R3570 DGND.n497 DGND.t777 38.5719
R3571 DGND.n497 DGND.t418 38.5719
R3572 DGND.n34 DGND.t484 38.5719
R3573 DGND.n34 DGND.t790 38.5719
R3574 DGND.n387 DGND.t376 38.5719
R3575 DGND.n387 DGND.t60 38.5719
R3576 DGND.n398 DGND.t66 38.5719
R3577 DGND.n398 DGND.t742 38.5719
R3578 DGND.n404 DGND.t271 38.5719
R3579 DGND.n404 DGND.t847 38.5719
R3580 DGND.n412 DGND.t849 38.5719
R3581 DGND.n412 DGND.t719 38.5719
R3582 DGND.n52 DGND.t875 38.5719
R3583 DGND.n52 DGND.t522 38.5719
R3584 DGND.n56 DGND.t250 38.5719
R3585 DGND.n56 DGND.t873 38.5719
R3586 DGND.n57 DGND.t277 38.5719
R3587 DGND.n57 DGND.t20 38.5719
R3588 DGND.n61 DGND.t141 38.5719
R3589 DGND.n61 DGND.t279 38.5719
R3590 DGND.n365 DGND.t90 38.5719
R3591 DGND.n365 DGND.t78 38.5719
R3592 DGND.n368 DGND.t46 38.5719
R3593 DGND.n368 DGND.t86 38.5719
R3594 DGND.n371 DGND.t17 38.5719
R3595 DGND.n371 DGND.t256 38.5719
R3596 DGND.n374 DGND.t541 38.5719
R3597 DGND.n374 DGND.t224 38.5719
R3598 DGND.n42 DGND.t118 38.5719
R3599 DGND.n42 DGND.t488 38.5719
R3600 DGND.n90 DGND.t629 38.5719
R3601 DGND.n90 DGND.t738 38.5719
R3602 DGND.n87 DGND.t213 38.5719
R3603 DGND.n87 DGND.t623 38.5719
R3604 DGND.n82 DGND.t781 38.5719
R3605 DGND.n82 DGND.t740 38.5719
R3606 DGND.n154 DGND.t657 38.5719
R3607 DGND.n154 DGND.t783 38.5719
R3608 DGND.n161 DGND.t496 38.5719
R3609 DGND.n161 DGND.t425 38.5719
R3610 DGND.n169 DGND.t634 38.5719
R3611 DGND.n169 DGND.t500 38.5719
R3612 DGND.n279 DGND.t354 38.5719
R3613 DGND.n279 DGND.t24 38.5719
R3614 DGND.n282 DGND.t504 38.5719
R3615 DGND.n282 DGND.t358 38.5719
R3616 DGND.n288 DGND.t834 38.5719
R3617 DGND.n288 DGND.t670 38.5719
R3618 DGND.n292 DGND.t824 38.5719
R3619 DGND.n292 DGND.t830 38.5719
R3620 DGND.n295 DGND.t98 38.5719
R3621 DGND.n295 DGND.t554 38.5719
R3622 DGND.n298 DGND.t683 38.5719
R3623 DGND.n298 DGND.t92 38.5719
R3624 DGND.n224 DGND.t446 38.5719
R3625 DGND.n224 DGND.t384 38.5719
R3626 DGND.n221 DGND.t40 38.5719
R3627 DGND.n221 DGND.t573 38.5719
R3628 DGND.n186 DGND.t231 38.5719
R3629 DGND.n186 DGND.t711 38.5719
R3630 DGND.n201 DGND.t715 38.5719
R3631 DGND.n201 DGND.t751 38.5719
R3632 DGND.n1033 DGND.t192 38.5719
R3633 DGND.n1033 DGND.t429 38.5719
R3634 DGND.n1036 DGND.t545 38.5719
R3635 DGND.n1036 DGND.t190 38.5719
R3636 DGND.n1043 DGND.t317 38.5719
R3637 DGND.n1043 DGND.t312 38.5719
R3638 DGND.n1046 DGND.t173 38.5719
R3639 DGND.n1046 DGND.t319 38.5719
R3640 DGND.n1017 DGND.n15 34.6358
R3641 DGND.n1018 DGND.n1017 34.6358
R3642 DGND.n1019 DGND.n1018 34.6358
R3643 DGND.n1019 DGND.n13 34.6358
R3644 DGND.n1024 DGND.n13 34.6358
R3645 DGND.n1025 DGND.n1024 34.6358
R3646 DGND.n1011 DGND.n1010 34.6358
R3647 DGND.n1013 DGND.n1011 34.6358
R3648 DGND.n1006 DGND.n1005 34.6358
R3649 DGND.n1007 DGND.n1006 34.6358
R3650 DGND.n1000 DGND.n21 34.6358
R3651 DGND.n1001 DGND.n1000 34.6358
R3652 DGND.n1002 DGND.n1001 34.6358
R3653 DGND.n996 DGND.n993 34.6358
R3654 DGND.n985 DGND.n26 34.6358
R3655 DGND.n986 DGND.n985 34.6358
R3656 DGND.n987 DGND.n986 34.6358
R3657 DGND.n809 DGND.n794 34.6358
R3658 DGND.n805 DGND.n803 34.6358
R3659 DGND.n972 DGND.n971 34.6358
R3660 DGND.n957 DGND.n823 34.6358
R3661 DGND.n952 DGND.n951 34.6358
R3662 DGND.n936 DGND.n935 34.6358
R3663 DGND.n930 DGND.n929 34.6358
R3664 DGND.n924 DGND.n923 34.6358
R3665 DGND.n920 DGND.n919 34.6358
R3666 DGND.n917 DGND.n843 34.6358
R3667 DGND.n913 DGND.n912 34.6358
R3668 DGND.n902 DGND.n901 34.6358
R3669 DGND.n901 DGND.n900 34.6358
R3670 DGND.n885 DGND.n884 34.6358
R3671 DGND.n874 DGND.n873 34.6358
R3672 DGND.n873 DGND.n872 34.6358
R3673 DGND.n782 DGND.n781 34.6358
R3674 DGND.n776 DGND.n775 34.6358
R3675 DGND.n775 DGND.n774 34.6358
R3676 DGND.n771 DGND.n770 34.6358
R3677 DGND.n761 DGND.n721 34.6358
R3678 DGND.n757 DGND.n756 34.6358
R3679 DGND.n744 DGND.n743 34.6358
R3680 DGND.n1181 DGND.n1180 34.6358
R3681 DGND.n1180 DGND.n1179 34.6358
R3682 DGND.n1179 DGND.n6 34.6358
R3683 DGND.n1175 DGND.n1174 34.6358
R3684 DGND.n1165 DGND.n1102 34.6358
R3685 DGND.n1161 DGND.n1160 34.6358
R3686 DGND.n1154 DGND.n1153 34.6358
R3687 DGND.n1150 DGND.n1110 34.6358
R3688 DGND.n1146 DGND.n1110 34.6358
R3689 DGND.n1142 DGND.n1112 34.6358
R3690 DGND.n1138 DGND.n1112 34.6358
R3691 DGND.n1132 DGND.n1131 34.6358
R3692 DGND.n1125 DGND.n1124 34.6358
R3693 DGND.n695 DGND.n694 34.6358
R3694 DGND.n696 DGND.n695 34.6358
R3695 DGND.n696 DGND.n686 34.6358
R3696 DGND.n700 DGND.n686 34.6358
R3697 DGND.n505 DGND.n504 34.6358
R3698 DGND.n675 DGND.n498 34.6358
R3699 DGND.n667 DGND.n517 34.6358
R3700 DGND.n663 DGND.n517 34.6358
R3701 DGND.n654 DGND.n653 34.6358
R3702 DGND.n653 DGND.n521 34.6358
R3703 DGND.n639 DGND.n529 34.6358
R3704 DGND.n635 DGND.n529 34.6358
R3705 DGND.n628 DGND.n627 34.6358
R3706 DGND.n613 DGND.n612 34.6358
R3707 DGND.n610 DGND.n547 34.6358
R3708 DGND.n602 DGND.n550 34.6358
R3709 DGND.n598 DGND.n597 34.6358
R3710 DGND.n597 DGND.n596 34.6358
R3711 DGND.n585 DGND.n584 34.6358
R3712 DGND.n581 DGND.n560 34.6358
R3713 DGND.n573 DGND.n564 34.6358
R3714 DGND.n510 DGND.n509 34.6358
R3715 DGND.n511 DGND.n510 34.6358
R3716 DGND.n511 DGND.n496 34.6358
R3717 DGND.n394 DGND.n384 34.6358
R3718 DGND.n403 DGND.n382 34.6358
R3719 DGND.n407 DGND.n406 34.6358
R3720 DGND.n420 DGND.n419 34.6358
R3721 DGND.n419 DGND.n418 34.6358
R3722 DGND.n418 DGND.n377 34.6358
R3723 DGND.n475 DGND.n474 34.6358
R3724 DGND.n471 DGND.n58 34.6358
R3725 DGND.n467 DGND.n466 34.6358
R3726 DGND.n463 DGND.n62 34.6358
R3727 DGND.n459 DGND.n62 34.6358
R3728 DGND.n455 DGND.n64 34.6358
R3729 DGND.n451 DGND.n64 34.6358
R3730 DGND.n435 DGND.n434 34.6358
R3731 DGND.n432 DGND.n369 34.6358
R3732 DGND.n424 DGND.n372 34.6358
R3733 DGND.n41 DGND.n40 34.6358
R3734 DGND.n44 DGND.n29 34.6358
R3735 DGND.n492 DGND.n30 34.6358
R3736 DGND.n112 DGND.n95 34.6358
R3737 DGND.n113 DGND.n112 34.6358
R3738 DGND.n106 DGND.n105 34.6358
R3739 DGND.n108 DGND.n106 34.6358
R3740 DGND.n129 DGND.n128 34.6358
R3741 DGND.n140 DGND.n139 34.6358
R3742 DGND.n140 DGND.n83 34.6358
R3743 DGND.n144 DGND.n83 34.6358
R3744 DGND.n149 DGND.n147 34.6358
R3745 DGND.n153 DGND.n152 34.6358
R3746 DGND.n156 DGND.n78 34.6358
R3747 DGND.n160 DGND.n78 34.6358
R3748 DGND.n168 DGND.n167 34.6358
R3749 DGND.n275 DGND.n71 34.6358
R3750 DGND.n358 DGND.n72 34.6358
R3751 DGND.n350 DGND.n280 34.6358
R3752 DGND.n346 DGND.n345 34.6358
R3753 DGND.n345 DGND.n344 34.6358
R3754 DGND.n344 DGND.n285 34.6358
R3755 DGND.n335 DGND.n334 34.6358
R3756 DGND.n331 DGND.n293 34.6358
R3757 DGND.n327 DGND.n293 34.6358
R3758 DGND.n327 DGND.n326 34.6358
R3759 DGND.n318 DGND.n317 34.6358
R3760 DGND.n312 DGND.n301 34.6358
R3761 DGND.n118 DGND.n93 34.6358
R3762 DGND.n119 DGND.n118 34.6358
R3763 DGND.n235 DGND.n234 34.6358
R3764 DGND.n234 DGND.n233 34.6358
R3765 DGND.n241 DGND.n240 34.6358
R3766 DGND.n240 DGND.n239 34.6358
R3767 DGND.n239 DGND.n227 34.6358
R3768 DGND.n245 DGND.n244 34.6358
R3769 DGND.n253 DGND.n219 34.6358
R3770 DGND.n253 DGND.n252 34.6358
R3771 DGND.n252 DGND.n251 34.6358
R3772 DGND.n259 DGND.n258 34.6358
R3773 DGND.n265 DGND.n176 34.6358
R3774 DGND.n265 DGND.n264 34.6358
R3775 DGND.n194 DGND.n193 34.6358
R3776 DGND.n193 DGND.n192 34.6358
R3777 DGND.n192 DGND.n189 34.6358
R3778 DGND.n198 DGND.n184 34.6358
R3779 DGND.n208 DGND.n207 34.6358
R3780 DGND.n207 DGND.n206 34.6358
R3781 DGND.n206 DGND.n182 34.6358
R3782 DGND.n213 DGND.n212 34.6358
R3783 DGND.n1027 DGND.n10 34.6358
R3784 DGND.n1090 DGND.n11 34.6358
R3785 DGND.n1085 DGND.n1084 34.6358
R3786 DGND.n1084 DGND.n1031 34.6358
R3787 DGND.n1080 DGND.n1031 34.6358
R3788 DGND.n1075 DGND.n1074 34.6358
R3789 DGND.n1072 DGND.n1037 34.6358
R3790 DGND.n1068 DGND.n1037 34.6358
R3791 DGND.n1068 DGND.n1067 34.6358
R3792 DGND.n1065 DGND.n1039 34.6358
R3793 DGND.n1060 DGND.n1059 34.6358
R3794 DGND.n1059 DGND.n1041 34.6358
R3795 DGND.n1055 DGND.n1041 34.6358
R3796 DGND.n1050 DGND.n1049 34.6358
R3797 DGND.n309 DGND.n306 34.2118
R3798 DGND.n813 DGND.n812 33.8829
R3799 DGND.n907 DGND.n848 33.8829
R3800 DGND.n768 DGND.n717 33.8829
R3801 DGND.n1172 DGND.n1098 33.8829
R3802 DGND.n663 DGND.n662 33.8829
R3803 DGND.n596 DGND.n554 33.8829
R3804 DGND.n577 DGND.n576 33.8829
R3805 DGND.n459 DGND.n458 33.8829
R3806 DGND.t859 DGND.t590 33.717
R3807 DGND.t136 DGND.t128 33.717
R3808 DGND.t569 DGND.t14 33.717
R3809 DGND.t214 DGND.t620 33.717
R3810 DGND.t530 DGND.t734 33.717
R3811 DGND.t475 DGND.t286 33.717
R3812 DGND.n991 DGND.n24 32.7534
R3813 DGND.n946 DGND.n945 32.7534
R3814 DGND.n929 DGND.n837 32.7534
R3815 DGND.n895 DGND.n894 32.7534
R3816 DGND.n755 DGND.n754 32.7534
R3817 DGND.n743 DGND.n742 32.7534
R3818 DGND.n1146 DGND.n1145 32.7534
R3819 DGND.n1136 DGND.n1135 32.7534
R3820 DGND.n691 DGND.n688 32.7534
R3821 DGND.n606 DGND.n605 32.7534
R3822 DGND.n399 DGND.n397 32.7534
R3823 DGND.n479 DGND.n478 32.7534
R3824 DGND.n428 DGND.n427 32.7534
R3825 DGND.n126 DGND.n91 32.7534
R3826 DGND.n134 DGND.n85 32.7534
R3827 DGND.n272 DGND.n271 32.7534
R3828 DGND.n354 DGND.n353 32.7534
R3829 DGND.n339 DGND.n338 32.7534
R3830 DGND.n320 DGND.n296 32.7534
R3831 DGND.n247 DGND.n222 32.7534
R3832 DGND.n202 DGND.n200 32.7534
R3833 DGND.n1079 DGND.n1078 32.7534
R3834 DGND.n1054 DGND.n1053 32.7534
R3835 DGND.n1159 DGND.n1158 32.0005
R3836 DGND.n36 DGND.n35 32.0005
R3837 DGND.n618 DGND.n617 30.8711
R3838 DGND.n413 DGND.n411 30.8711
R3839 DGND.n440 DGND.n439 30.8711
R3840 DGND.n704 DGND.n703 29.3652
R3841 DGND.n959 DGND.n820 27.4829
R3842 DGND.n906 DGND.n905 27.4829
R3843 DGND.n977 DGND.n790 27.4829
R3844 DGND.n822 DGND.t597 25.4291
R3845 DGND.t680 DGND.t493 25.2879
R3846 DGND.t792 DGND.t345 25.2879
R3847 DGND.n792 DGND.t808 24.9236
R3848 DGND.n792 DGND.t806 24.9236
R3849 DGND.n819 DGND.t194 24.9236
R3850 DGND.n819 DGND.t198 24.9236
R3851 DGND.n847 DGND.t512 24.9236
R3852 DGND.n847 DGND.t510 24.9236
R3853 DGND.n867 DGND.t674 24.9236
R3854 DGND.n867 DGND.t676 24.9236
R3855 DGND.n685 DGND.t165 24.9236
R3856 DGND.n685 DGND.t169 24.9236
R3857 DGND.n27 DGND.n26 24.0946
R3858 DGND.n802 DGND.n801 24.0946
R3859 DGND.n953 DGND.n952 24.0946
R3860 DGND.n947 DGND.n825 24.0946
R3861 DGND.n919 DGND.n918 24.0946
R3862 DGND.n896 DGND.n853 24.0946
R3863 DGND.n780 DGND.n779 24.0946
R3864 DGND.n774 DGND.n714 24.0946
R3865 DGND.n762 DGND.n761 24.0946
R3866 DGND.n1166 DGND.n1165 24.0946
R3867 DGND.n655 DGND.n654 24.0946
R3868 DGND.n626 DGND.n625 24.0946
R3869 DGND.n590 DGND.n589 24.0946
R3870 DGND.n584 DGND.n583 24.0946
R3871 DGND.n509 DGND.n500 24.0946
R3872 DGND.n486 DGND.n485 24.0946
R3873 DGND.n448 DGND.n447 24.0946
R3874 DGND.n145 DGND.n144 24.0946
R3875 DGND.n114 DGND.n93 24.0946
R3876 DGND.n257 DGND.n219 24.0946
R3877 DGND.n208 DGND.n180 24.0946
R3878 DGND.n1086 DGND.n1085 24.0946
R3879 DGND.n1061 DGND.n1060 24.0946
R3880 DGND.n973 DGND.n972 23.7181
R3881 DGND.n879 DGND.n878 23.7181
R3882 DGND.n878 DGND.n877 23.7181
R3883 DGND.n973 DGND.n789 23.7181
R3884 DGND.n1125 DGND.n1120 23.7181
R3885 DGND.n621 DGND.n539 23.7181
R3886 DGND.n585 DGND.n557 23.7181
R3887 DGND.n569 DGND.n568 23.7181
R3888 DGND.n481 DGND.n50 23.7181
R3889 DGND.n443 DGND.n69 23.7181
R3890 DGND.n134 DGND.n133 23.7181
R3891 DGND.n271 DGND.n74 23.7181
R3892 DGND.n313 DGND.n312 23.7181
R3893 DGND.n263 DGND.n177 23.7181
R3894 DGND.n702 DGND.n701 23.3417
R3895 DGND.n959 DGND.n958 22.9652
R3896 DGND.n1138 DGND.n1137 22.2123
R3897 DGND.n1129 DGND.n1120 22.2123
R3898 DGND.n625 DGND.n539 22.2123
R3899 DGND.n589 DGND.n557 22.2123
R3900 DGND.n569 DGND.n564 22.2123
R3901 DGND.n390 DGND.n389 22.2123
R3902 DGND.n488 DGND.n487 22.2123
R3903 DGND.n485 DGND.n50 22.2123
R3904 DGND.n451 DGND.n450 22.2123
R3905 DGND.n447 DGND.n69 22.2123
R3906 DGND.n133 DGND.n132 22.2123
R3907 DGND.n171 DGND.n74 22.2123
R3908 DGND.n314 DGND.n313 22.2123
R3909 DGND.n233 DGND.n230 22.2123
R3910 DGND.n264 DGND.n263 22.2123
R3911 DGND.n964 DGND.n963 21.4593
R3912 DGND.n958 DGND.n957 21.4593
R3913 DGND.n951 DGND.n825 20.3299
R3914 DGND.n900 DGND.n853 20.3299
R3915 DGND.n781 DGND.n780 20.3299
R3916 DGND.n763 DGND.n762 20.3299
R3917 DGND.n1167 DGND.n1166 20.3299
R3918 DGND.n505 DGND.n500 20.3299
R3919 DGND.n659 DGND.n519 20.3299
R3920 DGND.n627 DGND.n626 20.3299
R3921 DGND.n591 DGND.n590 20.3299
R3922 DGND.n481 DGND.n480 20.3299
R3923 DGND.n114 DGND.n113 20.3299
R3924 DGND.n258 DGND.n257 20.3299
R3925 DGND.n212 DGND.n180 20.3299
R3926 DGND.n1086 DGND.n11 20.3299
R3927 DGND.n1061 DGND.n1039 20.3299
R3928 DGND.n953 DGND.n823 19.9534
R3929 DGND.n870 DGND.n869 19.8544
R3930 DGND.n810 DGND.n809 19.577
R3931 DGND.n912 DGND.n911 19.577
R3932 DGND.n765 DGND.n764 19.577
R3933 DGND.n1169 DGND.n1168 19.577
R3934 DGND.n1153 DGND.n1152 19.577
R3935 DGND.n575 DGND.n574 19.577
R3936 DGND.n474 DGND.n473 19.577
R3937 DGND.n375 DGND.n372 19.577
R3938 DGND.n283 DGND.n280 19.577
R3939 DGND.n334 DGND.n333 19.577
R3940 DGND.n925 DGND.n924 19.2005
R3941 DGND.n1181 DGND.n5 19.2005
R3942 DGND.n1143 DGND.n1142 19.2005
R3943 DGND.n660 DGND.n659 19.2005
R3944 DGND.n592 DGND.n591 19.2005
R3945 DGND.n456 DGND.n455 19.2005
R3946 DGND.n139 DGND.n138 19.2005
R3947 DGND.n275 DGND.n274 19.2005
R3948 DGND.n869 DGND.n868 18.4476
R3949 DGND.n1123 DGND.n1122 18.4476
R3950 DGND.n308 DGND.n307 18.4476
R3951 DGND.n103 DGND.n97 18.1425
R3952 DGND.n215 DGND.n214 18.1423
R3953 DGND.n1157 DGND.n1107 18.0711
R3954 DGND.n1135 DGND.n1116 18.0711
R3955 DGND.n706 DGND.n705 18.0711
R3956 DGND.n616 DGND.n544 18.0711
R3957 DGND.n410 DGND.n380 18.0711
R3958 DGND.n438 DGND.n366 18.0711
R3959 DGND.n37 DGND.n32 18.0711
R3960 DGND.n149 DGND.n148 18.0711
R3961 DGND.n353 DGND.n352 18.0711
R3962 DGND.n338 DGND.n289 18.0711
R3963 DGND.n799 DGND.n797 18.0436
R3964 DGND.n503 DGND.n502 17.8283
R3965 DGND.n923 DGND.n840 17.3181
R3966 DGND.n920 DGND.n840 17.3181
R3967 DGND.n852 DGND.n850 17.3181
R3968 DGND.n751 DGND.n750 17.3181
R3969 DGND.n750 DGND.n749 17.3181
R3970 DGND.n747 DGND.n739 17.3181
R3971 DGND.n744 DGND.n739 17.3181
R3972 DGND.n1096 DGND.n6 17.3181
R3973 DGND.n786 DGND.n680 17.3181
R3974 DGND.n786 DGND.n785 17.3181
R3975 DGND.n631 DGND.n536 17.3181
R3976 DGND.n628 DGND.n536 17.3181
R3977 DGND.n621 DGND.n620 17.3181
R3978 DGND.n620 DGND.n619 17.3181
R3979 DGND.n677 DGND.n496 17.3181
R3980 DGND.n443 DGND.n442 17.3181
R3981 DGND.n442 DGND.n441 17.3181
R3982 DGND.n493 DGND.n29 17.3181
R3983 DGND.n493 DGND.n492 17.3181
R3984 DGND.n359 DGND.n71 17.3181
R3985 DGND.n359 DGND.n358 17.3181
R3986 DGND.n121 DGND.n119 17.3181
R3987 DGND.n122 DGND.n121 17.3181
R3988 DGND.n218 DGND.n177 17.3181
R3989 DGND.n259 DGND.n218 17.3181
R3990 DGND.n1091 DGND.n10 17.3181
R3991 DGND.n1091 DGND.n1090 17.3181
R3992 DGND.n813 DGND.n790 16.9417
R3993 DGND.n963 DGND.n820 16.9417
R3994 DGND.n907 DGND.n906 16.9417
R3995 DGND.t4 DGND.t347 16.8587
R3996 DGND.n1154 DGND.n1107 16.5652
R3997 DGND.n705 DGND.n680 16.5652
R3998 DGND.n613 DGND.n544 16.5652
R3999 DGND.n603 DGND.n602 16.5652
R4000 DGND.n395 DGND.n394 16.5652
R4001 DGND.n407 DGND.n380 16.5652
R4002 DGND.n435 DGND.n366 16.5652
R4003 DGND.n425 DGND.n424 16.5652
R4004 DGND.n40 DGND.n32 16.5652
R4005 DGND.n1118 DGND.n1116 15.8123
R4006 DGND.n352 DGND.n351 15.8123
R4007 DGND.n291 DGND.n289 15.8123
R4008 DGND.n926 DGND.n925 15.4358
R4009 DGND.n905 DGND.n850 15.4358
R4010 DGND.n741 DGND.n5 15.4358
R4011 DGND.n1144 DGND.n1143 15.4358
R4012 DGND.n1124 DGND.n1123 15.4358
R4013 DGND.n661 DGND.n660 15.4358
R4014 DGND.n605 DGND.n604 15.4358
R4015 DGND.n593 DGND.n592 15.4358
R4016 DGND.n397 DGND.n396 15.4358
R4017 DGND.n466 DGND.n465 15.4358
R4018 DGND.n457 DGND.n456 15.4358
R4019 DGND.n427 DGND.n426 15.4358
R4020 DGND.n138 DGND.n137 15.4358
R4021 DGND.n274 DGND.n273 15.4358
R4022 DGND.n307 DGND.n301 15.4358
R4023 DGND.n811 DGND.n810 15.0593
R4024 DGND.n911 DGND.n910 15.0593
R4025 DGND.n764 DGND.n763 15.0593
R4026 DGND.n1168 DGND.n1167 15.0593
R4027 DGND.n574 DGND.n573 15.0593
R4028 DGND.n464 DGND.n463 15.0593
R4029 DGND.n148 DGND.n80 14.6829
R4030 DGND.n1152 DGND.n1151 14.3064
R4031 DGND.n376 DGND.n375 13.177
R4032 DGND.n284 DGND.n283 13.177
R4033 DGND.n333 DGND.n332 13.177
R4034 DGND.n690 DGND.n689 12.3761
R4035 DGND.n567 DGND.n566 11.8242
R4036 DGND.n971 DGND.n817 11.7085
R4037 DGND.n987 DGND.n24 11.6711
R4038 DGND.n947 DGND.n946 11.6711
R4039 DGND.n942 DGND.n941 11.6711
R4040 DGND.n896 DGND.n895 11.6711
R4041 DGND.n891 DGND.n890 11.6711
R4042 DGND.n756 DGND.n755 11.6711
R4043 DGND.n1160 DGND.n1159 11.6711
R4044 DGND.n649 DGND.n521 11.6711
R4045 DGND.n619 DGND.n618 11.6711
R4046 DGND.n606 DGND.n547 11.6711
R4047 DGND.n399 DGND.n382 11.6711
R4048 DGND.n414 DGND.n413 11.6711
R4049 DGND.n441 DGND.n440 11.6711
R4050 DGND.n428 DGND.n369 11.6711
R4051 DGND.n162 DGND.n160 11.6711
R4052 DGND.n354 DGND.n72 11.6711
R4053 DGND.n340 DGND.n339 11.6711
R4054 DGND.n324 DGND.n296 11.6711
R4055 DGND.n122 DGND.n91 11.6711
R4056 DGND.n251 DGND.n222 11.6711
R4057 DGND.n202 DGND.n182 11.6711
R4058 DGND.n1080 DGND.n1079 11.6711
R4059 DGND.n1055 DGND.n1054 11.6711
R4060 DGND.n450 DGND.n449 11.2946
R4061 DGND.n967 DGND.n964 10.5791
R4062 DGND.n1026 DGND.n1025 10.5417
R4063 DGND.n1013 DGND.n1012 10.5417
R4064 DGND.n1007 DGND.n17 10.5417
R4065 DGND.n803 DGND.n802 10.5417
R4066 DGND.n918 DGND.n917 10.5417
R4067 DGND.n1175 DGND.n1097 10.5417
R4068 DGND.n703 DGND.n702 10.5417
R4069 DGND.n671 DGND.n670 10.5417
R4070 DGND.n676 DGND.n675 10.5417
R4071 DGND.n472 DGND.n471 10.5417
R4072 DGND.n108 DGND.n107 10.5417
R4073 DGND.n1048 DGND.n1047 10.2049
R4074 DGND.n1122 DGND.n1121 10.1732
R4075 DGND.n716 DGND.n714 9.78874
R4076 DGND.n655 DGND.n519 9.78874
R4077 DGND.n649 DGND.n648 9.78874
R4078 DGND.n583 DGND.n582 9.78874
R4079 DGND.n146 DGND.n145 9.78874
R4080 DGND.n487 DGND.n486 9.41227
R4081 DGND.n449 DGND.n448 9.41227
R4082 DGND.n872 DGND.n871 9.3005
R4083 DGND.n873 DGND.n866 9.3005
R4084 DGND.n875 DGND.n874 9.3005
R4085 DGND.n877 DGND.n876 9.3005
R4086 DGND.n878 DGND.n864 9.3005
R4087 DGND.n801 DGND.n800 9.3005
R4088 DGND.n803 DGND.n795 9.3005
R4089 DGND.n806 DGND.n805 9.3005
R4090 DGND.n807 DGND.n794 9.3005
R4091 DGND.n809 DGND.n808 9.3005
R4092 DGND.n811 DGND.n791 9.3005
R4093 DGND.n814 DGND.n813 9.3005
R4094 DGND.n815 DGND.n790 9.3005
R4095 DGND.n972 DGND.n816 9.3005
R4096 DGND.n971 DGND.n970 9.3005
R4097 DGND.n969 DGND.n968 9.3005
R4098 DGND.n964 DGND.n818 9.3005
R4099 DGND.n963 DGND.n962 9.3005
R4100 DGND.n961 DGND.n820 9.3005
R4101 DGND.n960 DGND.n959 9.3005
R4102 DGND.n958 DGND.n821 9.3005
R4103 DGND.n957 DGND.n956 9.3005
R4104 DGND.n955 DGND.n823 9.3005
R4105 DGND.n954 DGND.n953 9.3005
R4106 DGND.n952 DGND.n824 9.3005
R4107 DGND.n951 DGND.n950 9.3005
R4108 DGND.n949 DGND.n825 9.3005
R4109 DGND.n948 DGND.n947 9.3005
R4110 DGND.n946 DGND.n826 9.3005
R4111 DGND.n945 DGND.n944 9.3005
R4112 DGND.n943 DGND.n942 9.3005
R4113 DGND.n941 DGND.n829 9.3005
R4114 DGND.n939 DGND.n938 9.3005
R4115 DGND.n937 DGND.n936 9.3005
R4116 DGND.n935 DGND.n833 9.3005
R4117 DGND.n933 DGND.n932 9.3005
R4118 DGND.n931 DGND.n930 9.3005
R4119 DGND.n929 DGND.n928 9.3005
R4120 DGND.n927 DGND.n926 9.3005
R4121 DGND.n924 DGND.n838 9.3005
R4122 DGND.n923 DGND.n922 9.3005
R4123 DGND.n921 DGND.n920 9.3005
R4124 DGND.n919 DGND.n841 9.3005
R4125 DGND.n917 DGND.n916 9.3005
R4126 DGND.n915 DGND.n843 9.3005
R4127 DGND.n914 DGND.n913 9.3005
R4128 DGND.n912 DGND.n844 9.3005
R4129 DGND.n910 DGND.n909 9.3005
R4130 DGND.n908 DGND.n907 9.3005
R4131 DGND.n906 DGND.n849 9.3005
R4132 DGND.n905 DGND.n904 9.3005
R4133 DGND.n903 DGND.n902 9.3005
R4134 DGND.n901 DGND.n851 9.3005
R4135 DGND.n900 DGND.n899 9.3005
R4136 DGND.n898 DGND.n853 9.3005
R4137 DGND.n897 DGND.n896 9.3005
R4138 DGND.n895 DGND.n854 9.3005
R4139 DGND.n894 DGND.n893 9.3005
R4140 DGND.n892 DGND.n891 9.3005
R4141 DGND.n890 DGND.n857 9.3005
R4142 DGND.n888 DGND.n887 9.3005
R4143 DGND.n886 DGND.n885 9.3005
R4144 DGND.n884 DGND.n861 9.3005
R4145 DGND.n882 DGND.n881 9.3005
R4146 DGND.n880 DGND.n879 9.3005
R4147 DGND.n974 DGND.n973 9.3005
R4148 DGND.n975 DGND.n789 9.3005
R4149 DGND.n977 DGND.n976 9.3005
R4150 DGND.n783 DGND.n782 9.3005
R4151 DGND.n781 DGND.n709 9.3005
R4152 DGND.n780 DGND.n710 9.3005
R4153 DGND.n779 DGND.n778 9.3005
R4154 DGND.n777 DGND.n776 9.3005
R4155 DGND.n775 DGND.n712 9.3005
R4156 DGND.n774 DGND.n773 9.3005
R4157 DGND.n772 DGND.n771 9.3005
R4158 DGND.n770 DGND.n715 9.3005
R4159 DGND.n768 DGND.n767 9.3005
R4160 DGND.n766 DGND.n765 9.3005
R4161 DGND.n763 DGND.n718 9.3005
R4162 DGND.n762 DGND.n720 9.3005
R4163 DGND.n761 DGND.n760 9.3005
R4164 DGND.n759 DGND.n721 9.3005
R4165 DGND.n758 DGND.n757 9.3005
R4166 DGND.n756 DGND.n722 9.3005
R4167 DGND.n755 DGND.n725 9.3005
R4168 DGND.n754 DGND.n753 9.3005
R4169 DGND.n752 DGND.n751 9.3005
R4170 DGND.n749 DGND.n727 9.3005
R4171 DGND.n747 DGND.n746 9.3005
R4172 DGND.n745 DGND.n744 9.3005
R4173 DGND.n743 DGND.n740 9.3005
R4174 DGND.n741 DGND.n3 9.3005
R4175 DGND.n1182 DGND.n1181 9.3005
R4176 DGND.n1180 DGND.n4 9.3005
R4177 DGND.n1179 DGND.n1178 9.3005
R4178 DGND.n1177 DGND.n6 9.3005
R4179 DGND.n1176 DGND.n1175 9.3005
R4180 DGND.n1174 DGND.n7 9.3005
R4181 DGND.n1172 DGND.n1171 9.3005
R4182 DGND.n1170 DGND.n1169 9.3005
R4183 DGND.n1167 DGND.n1099 9.3005
R4184 DGND.n1166 DGND.n1101 9.3005
R4185 DGND.n1165 DGND.n1164 9.3005
R4186 DGND.n1163 DGND.n1102 9.3005
R4187 DGND.n1162 DGND.n1161 9.3005
R4188 DGND.n1160 DGND.n1103 9.3005
R4189 DGND.n1159 DGND.n1106 9.3005
R4190 DGND.n1157 DGND.n1156 9.3005
R4191 DGND.n1155 DGND.n1154 9.3005
R4192 DGND.n1153 DGND.n1108 9.3005
R4193 DGND.n1150 DGND.n1149 9.3005
R4194 DGND.n1148 DGND.n1110 9.3005
R4195 DGND.n1147 DGND.n1146 9.3005
R4196 DGND.n1144 DGND.n1111 9.3005
R4197 DGND.n1142 DGND.n1141 9.3005
R4198 DGND.n1140 DGND.n1112 9.3005
R4199 DGND.n1139 DGND.n1138 9.3005
R4200 DGND.n1137 DGND.n1113 9.3005
R4201 DGND.n1136 DGND.n1114 9.3005
R4202 DGND.n1135 DGND.n1134 9.3005
R4203 DGND.n1133 DGND.n1132 9.3005
R4204 DGND.n1131 DGND.n1117 9.3005
R4205 DGND.n1129 DGND.n1128 9.3005
R4206 DGND.n1127 DGND.n1120 9.3005
R4207 DGND.n1126 DGND.n1125 9.3005
R4208 DGND.n1124 DGND.n1121 9.3005
R4209 DGND.n692 DGND.n691 9.3005
R4210 DGND.n694 DGND.n693 9.3005
R4211 DGND.n695 DGND.n687 9.3005
R4212 DGND.n697 DGND.n696 9.3005
R4213 DGND.n698 DGND.n686 9.3005
R4214 DGND.n700 DGND.n699 9.3005
R4215 DGND.n703 DGND.n683 9.3005
R4216 DGND.n707 DGND.n706 9.3005
R4217 DGND.n708 DGND.n680 9.3005
R4218 DGND.n785 DGND.n784 9.3005
R4219 DGND.n504 DGND.n501 9.3005
R4220 DGND.n506 DGND.n505 9.3005
R4221 DGND.n673 DGND.n498 9.3005
R4222 DGND.n672 DGND.n671 9.3005
R4223 DGND.n669 DGND.n514 9.3005
R4224 DGND.n667 DGND.n666 9.3005
R4225 DGND.n665 DGND.n517 9.3005
R4226 DGND.n664 DGND.n663 9.3005
R4227 DGND.n661 DGND.n518 9.3005
R4228 DGND.n659 DGND.n658 9.3005
R4229 DGND.n657 DGND.n519 9.3005
R4230 DGND.n656 DGND.n655 9.3005
R4231 DGND.n654 DGND.n520 9.3005
R4232 DGND.n653 DGND.n652 9.3005
R4233 DGND.n651 DGND.n521 9.3005
R4234 DGND.n650 DGND.n649 9.3005
R4235 DGND.n648 DGND.n522 9.3005
R4236 DGND.n646 DGND.n645 9.3005
R4237 DGND.n644 DGND.n643 9.3005
R4238 DGND.n641 DGND.n526 9.3005
R4239 DGND.n639 DGND.n638 9.3005
R4240 DGND.n637 DGND.n529 9.3005
R4241 DGND.n636 DGND.n635 9.3005
R4242 DGND.n633 DGND.n530 9.3005
R4243 DGND.n631 DGND.n630 9.3005
R4244 DGND.n629 DGND.n628 9.3005
R4245 DGND.n627 DGND.n537 9.3005
R4246 DGND.n626 DGND.n538 9.3005
R4247 DGND.n625 DGND.n624 9.3005
R4248 DGND.n623 DGND.n539 9.3005
R4249 DGND.n622 DGND.n621 9.3005
R4250 DGND.n619 DGND.n540 9.3005
R4251 DGND.n618 DGND.n542 9.3005
R4252 DGND.n616 DGND.n615 9.3005
R4253 DGND.n614 DGND.n613 9.3005
R4254 DGND.n612 DGND.n545 9.3005
R4255 DGND.n610 DGND.n609 9.3005
R4256 DGND.n608 DGND.n547 9.3005
R4257 DGND.n607 DGND.n606 9.3005
R4258 DGND.n605 DGND.n548 9.3005
R4259 DGND.n602 DGND.n601 9.3005
R4260 DGND.n600 DGND.n550 9.3005
R4261 DGND.n599 DGND.n598 9.3005
R4262 DGND.n597 DGND.n551 9.3005
R4263 DGND.n596 DGND.n595 9.3005
R4264 DGND.n594 DGND.n593 9.3005
R4265 DGND.n591 DGND.n555 9.3005
R4266 DGND.n590 DGND.n556 9.3005
R4267 DGND.n589 DGND.n588 9.3005
R4268 DGND.n587 DGND.n557 9.3005
R4269 DGND.n586 DGND.n585 9.3005
R4270 DGND.n584 DGND.n558 9.3005
R4271 DGND.n581 DGND.n580 9.3005
R4272 DGND.n579 DGND.n560 9.3005
R4273 DGND.n578 DGND.n577 9.3005
R4274 DGND.n575 DGND.n561 9.3005
R4275 DGND.n573 DGND.n572 9.3005
R4276 DGND.n571 DGND.n564 9.3005
R4277 DGND.n570 DGND.n569 9.3005
R4278 DGND.n568 DGND.n565 9.3005
R4279 DGND.n507 DGND.n500 9.3005
R4280 DGND.n509 DGND.n508 9.3005
R4281 DGND.n510 DGND.n499 9.3005
R4282 DGND.n512 DGND.n511 9.3005
R4283 DGND.n513 DGND.n496 9.3005
R4284 DGND.n675 DGND.n674 9.3005
R4285 DGND.n421 DGND.n420 9.3005
R4286 DGND.n391 DGND.n390 9.3005
R4287 DGND.n392 DGND.n384 9.3005
R4288 DGND.n394 DGND.n393 9.3005
R4289 DGND.n397 DGND.n383 9.3005
R4290 DGND.n400 DGND.n399 9.3005
R4291 DGND.n401 DGND.n382 9.3005
R4292 DGND.n403 DGND.n402 9.3005
R4293 DGND.n406 DGND.n381 9.3005
R4294 DGND.n408 DGND.n407 9.3005
R4295 DGND.n410 DGND.n409 9.3005
R4296 DGND.n413 DGND.n378 9.3005
R4297 DGND.n415 DGND.n414 9.3005
R4298 DGND.n416 DGND.n377 9.3005
R4299 DGND.n418 DGND.n417 9.3005
R4300 DGND.n419 DGND.n373 9.3005
R4301 DGND.n422 DGND.n372 9.3005
R4302 DGND.n424 DGND.n423 9.3005
R4303 DGND.n427 DGND.n370 9.3005
R4304 DGND.n429 DGND.n428 9.3005
R4305 DGND.n430 DGND.n369 9.3005
R4306 DGND.n432 DGND.n431 9.3005
R4307 DGND.n434 DGND.n367 9.3005
R4308 DGND.n436 DGND.n435 9.3005
R4309 DGND.n438 DGND.n437 9.3005
R4310 DGND.n440 DGND.n364 9.3005
R4311 DGND.n441 DGND.n70 9.3005
R4312 DGND.n444 DGND.n443 9.3005
R4313 DGND.n445 DGND.n69 9.3005
R4314 DGND.n489 DGND.n488 9.3005
R4315 DGND.n487 DGND.n47 9.3005
R4316 DGND.n486 DGND.n49 9.3005
R4317 DGND.n485 DGND.n484 9.3005
R4318 DGND.n483 DGND.n50 9.3005
R4319 DGND.n482 DGND.n481 9.3005
R4320 DGND.n480 DGND.n51 9.3005
R4321 DGND.n479 DGND.n53 9.3005
R4322 DGND.n478 DGND.n477 9.3005
R4323 DGND.n476 DGND.n475 9.3005
R4324 DGND.n474 DGND.n55 9.3005
R4325 DGND.n471 DGND.n470 9.3005
R4326 DGND.n469 DGND.n58 9.3005
R4327 DGND.n468 DGND.n467 9.3005
R4328 DGND.n466 DGND.n59 9.3005
R4329 DGND.n463 DGND.n462 9.3005
R4330 DGND.n461 DGND.n62 9.3005
R4331 DGND.n460 DGND.n459 9.3005
R4332 DGND.n457 DGND.n63 9.3005
R4333 DGND.n455 DGND.n454 9.3005
R4334 DGND.n453 DGND.n64 9.3005
R4335 DGND.n452 DGND.n451 9.3005
R4336 DGND.n450 DGND.n65 9.3005
R4337 DGND.n449 DGND.n66 9.3005
R4338 DGND.n448 DGND.n68 9.3005
R4339 DGND.n447 DGND.n446 9.3005
R4340 DGND.n38 DGND.n37 9.3005
R4341 DGND.n40 DGND.n39 9.3005
R4342 DGND.n41 DGND.n31 9.3005
R4343 DGND.n45 DGND.n44 9.3005
R4344 DGND.n46 DGND.n29 9.3005
R4345 DGND.n492 DGND.n491 9.3005
R4346 DGND.n490 DGND.n30 9.3005
R4347 DGND.n105 DGND.n104 9.3005
R4348 DGND.n106 DGND.n96 9.3005
R4349 DGND.n109 DGND.n108 9.3005
R4350 DGND.n110 DGND.n95 9.3005
R4351 DGND.n112 DGND.n111 9.3005
R4352 DGND.n113 DGND.n94 9.3005
R4353 DGND.n124 DGND.n91 9.3005
R4354 DGND.n126 DGND.n125 9.3005
R4355 DGND.n128 DGND.n89 9.3005
R4356 DGND.n130 DGND.n129 9.3005
R4357 DGND.n132 DGND.n131 9.3005
R4358 DGND.n133 DGND.n86 9.3005
R4359 DGND.n135 DGND.n134 9.3005
R4360 DGND.n137 DGND.n136 9.3005
R4361 DGND.n139 DGND.n84 9.3005
R4362 DGND.n141 DGND.n140 9.3005
R4363 DGND.n142 DGND.n83 9.3005
R4364 DGND.n144 DGND.n143 9.3005
R4365 DGND.n147 DGND.n81 9.3005
R4366 DGND.n150 DGND.n149 9.3005
R4367 DGND.n152 DGND.n151 9.3005
R4368 DGND.n153 DGND.n79 9.3005
R4369 DGND.n157 DGND.n156 9.3005
R4370 DGND.n158 DGND.n78 9.3005
R4371 DGND.n160 DGND.n159 9.3005
R4372 DGND.n162 DGND.n77 9.3005
R4373 DGND.n165 DGND.n164 9.3005
R4374 DGND.n167 DGND.n166 9.3005
R4375 DGND.n168 DGND.n75 9.3005
R4376 DGND.n172 DGND.n171 9.3005
R4377 DGND.n173 DGND.n74 9.3005
R4378 DGND.n271 DGND.n270 9.3005
R4379 DGND.n273 DGND.n73 9.3005
R4380 DGND.n276 DGND.n275 9.3005
R4381 DGND.n277 DGND.n71 9.3005
R4382 DGND.n358 DGND.n357 9.3005
R4383 DGND.n356 DGND.n72 9.3005
R4384 DGND.n355 DGND.n354 9.3005
R4385 DGND.n353 DGND.n278 9.3005
R4386 DGND.n350 DGND.n349 9.3005
R4387 DGND.n348 DGND.n280 9.3005
R4388 DGND.n347 DGND.n346 9.3005
R4389 DGND.n345 DGND.n281 9.3005
R4390 DGND.n344 DGND.n343 9.3005
R4391 DGND.n342 DGND.n285 9.3005
R4392 DGND.n341 DGND.n340 9.3005
R4393 DGND.n339 DGND.n286 9.3005
R4394 DGND.n338 DGND.n337 9.3005
R4395 DGND.n336 DGND.n335 9.3005
R4396 DGND.n334 DGND.n290 9.3005
R4397 DGND.n331 DGND.n330 9.3005
R4398 DGND.n329 DGND.n293 9.3005
R4399 DGND.n328 DGND.n327 9.3005
R4400 DGND.n326 DGND.n294 9.3005
R4401 DGND.n324 DGND.n323 9.3005
R4402 DGND.n322 DGND.n296 9.3005
R4403 DGND.n321 DGND.n320 9.3005
R4404 DGND.n318 DGND.n297 9.3005
R4405 DGND.n317 DGND.n316 9.3005
R4406 DGND.n315 DGND.n314 9.3005
R4407 DGND.n313 DGND.n300 9.3005
R4408 DGND.n312 DGND.n311 9.3005
R4409 DGND.n310 DGND.n301 9.3005
R4410 DGND.n115 DGND.n114 9.3005
R4411 DGND.n116 DGND.n93 9.3005
R4412 DGND.n118 DGND.n117 9.3005
R4413 DGND.n119 DGND.n92 9.3005
R4414 DGND.n123 DGND.n122 9.3005
R4415 DGND.n209 DGND.n208 9.3005
R4416 DGND.n207 DGND.n181 9.3005
R4417 DGND.n206 DGND.n205 9.3005
R4418 DGND.n204 DGND.n182 9.3005
R4419 DGND.n203 DGND.n202 9.3005
R4420 DGND.n200 DGND.n183 9.3005
R4421 DGND.n198 DGND.n197 9.3005
R4422 DGND.n196 DGND.n184 9.3005
R4423 DGND.n195 DGND.n194 9.3005
R4424 DGND.n193 DGND.n185 9.3005
R4425 DGND.n192 DGND.n191 9.3005
R4426 DGND.n190 DGND.n189 9.3005
R4427 DGND.n176 DGND.n174 9.3005
R4428 DGND.n266 DGND.n265 9.3005
R4429 DGND.n264 DGND.n175 9.3005
R4430 DGND.n263 DGND.n262 9.3005
R4431 DGND.n261 DGND.n177 9.3005
R4432 DGND.n260 DGND.n259 9.3005
R4433 DGND.n258 DGND.n178 9.3005
R4434 DGND.n257 DGND.n256 9.3005
R4435 DGND.n255 DGND.n219 9.3005
R4436 DGND.n254 DGND.n253 9.3005
R4437 DGND.n252 DGND.n220 9.3005
R4438 DGND.n251 DGND.n250 9.3005
R4439 DGND.n249 DGND.n222 9.3005
R4440 DGND.n248 DGND.n247 9.3005
R4441 DGND.n245 DGND.n223 9.3005
R4442 DGND.n244 DGND.n243 9.3005
R4443 DGND.n242 DGND.n241 9.3005
R4444 DGND.n240 DGND.n226 9.3005
R4445 DGND.n239 DGND.n238 9.3005
R4446 DGND.n237 DGND.n227 9.3005
R4447 DGND.n236 DGND.n235 9.3005
R4448 DGND.n234 DGND.n228 9.3005
R4449 DGND.n233 DGND.n232 9.3005
R4450 DGND.n210 DGND.n180 9.3005
R4451 DGND.n213 DGND.n179 9.3005
R4452 DGND.n212 DGND.n211 9.3005
R4453 DGND.n1049 DGND.n1045 9.3005
R4454 DGND.n1051 DGND.n1050 9.3005
R4455 DGND.n1053 DGND.n1052 9.3005
R4456 DGND.n1054 DGND.n1042 9.3005
R4457 DGND.n1056 DGND.n1055 9.3005
R4458 DGND.n1057 DGND.n1041 9.3005
R4459 DGND.n1059 DGND.n1058 9.3005
R4460 DGND.n1060 DGND.n1040 9.3005
R4461 DGND.n1062 DGND.n1061 9.3005
R4462 DGND.n1063 DGND.n1039 9.3005
R4463 DGND.n1065 DGND.n1064 9.3005
R4464 DGND.n1067 DGND.n1038 9.3005
R4465 DGND.n1069 DGND.n1068 9.3005
R4466 DGND.n1070 DGND.n1037 9.3005
R4467 DGND.n1072 DGND.n1071 9.3005
R4468 DGND.n1074 DGND.n1035 9.3005
R4469 DGND.n1076 DGND.n1075 9.3005
R4470 DGND.n1078 DGND.n1077 9.3005
R4471 DGND.n1079 DGND.n1032 9.3005
R4472 DGND.n1081 DGND.n1080 9.3005
R4473 DGND.n1082 DGND.n1031 9.3005
R4474 DGND.n1084 DGND.n1083 9.3005
R4475 DGND.n1085 DGND.n1030 9.3005
R4476 DGND.n1087 DGND.n1086 9.3005
R4477 DGND.n1088 DGND.n11 9.3005
R4478 DGND.n1090 DGND.n1089 9.3005
R4479 DGND.n1029 DGND.n10 9.3005
R4480 DGND.n1028 DGND.n1027 9.3005
R4481 DGND.n983 DGND.n26 9.3005
R4482 DGND.n985 DGND.n984 9.3005
R4483 DGND.n986 DGND.n25 9.3005
R4484 DGND.n988 DGND.n987 9.3005
R4485 DGND.n989 DGND.n24 9.3005
R4486 DGND.n991 DGND.n990 9.3005
R4487 DGND.n993 DGND.n22 9.3005
R4488 DGND.n997 DGND.n996 9.3005
R4489 DGND.n998 DGND.n21 9.3005
R4490 DGND.n1000 DGND.n999 9.3005
R4491 DGND.n1001 DGND.n20 9.3005
R4492 DGND.n1003 DGND.n1002 9.3005
R4493 DGND.n1005 DGND.n1004 9.3005
R4494 DGND.n1006 DGND.n18 9.3005
R4495 DGND.n1008 DGND.n1007 9.3005
R4496 DGND.n1010 DGND.n1009 9.3005
R4497 DGND.n1011 DGND.n16 9.3005
R4498 DGND.n1014 DGND.n1013 9.3005
R4499 DGND.n1015 DGND.n15 9.3005
R4500 DGND.n1017 DGND.n1016 9.3005
R4501 DGND.n1018 DGND.n14 9.3005
R4502 DGND.n1020 DGND.n1019 9.3005
R4503 DGND.n1021 DGND.n13 9.3005
R4504 DGND.n1024 DGND.n1023 9.3005
R4505 DGND.n1025 DGND.n12 9.3005
R4506 DGND.t251 DGND.t160 8.42962
R4507 DGND.t47 DGND.t896 8.42962
R4508 DGND.t187 DGND.t102 8.42962
R4509 DGND.t162 DGND.t664 8.42962
R4510 DGND.n309 DGND.n308 8.35678
R4511 DGND.n996 DGND.n995 7.15344
R4512 DGND.n935 DGND.n934 7.15344
R4513 DGND.n884 DGND.n883 7.15344
R4514 DGND.n749 DGND.n748 7.15344
R4515 DGND.n1131 DGND.n1130 7.15344
R4516 DGND.n785 DGND.n682 7.15344
R4517 DGND.n669 DGND.n668 7.15344
R4518 DGND.n643 DGND.n642 7.15344
R4519 DGND.n641 DGND.n640 7.15344
R4520 DGND.n612 DGND.n611 7.15344
R4521 DGND.n553 DGND.n550 7.15344
R4522 DGND.n388 DGND.n384 7.15344
R4523 DGND.n406 DGND.n405 7.15344
R4524 DGND.n434 DGND.n433 7.15344
R4525 DGND.n43 DGND.n41 7.15344
R4526 DGND.n129 DGND.n88 7.15344
R4527 DGND.n155 DGND.n153 7.15344
R4528 DGND.n170 DGND.n168 7.15344
R4529 DGND.n317 DGND.n299 7.15344
R4530 DGND.n244 DGND.n225 7.15344
R4531 DGND.n187 DGND.n184 7.15344
R4532 DGND.n1074 DGND.n1073 7.15344
R4533 DGND.n1049 DGND.n1048 7.15344
R4534 DGND.n231 DGND.n230 7.07332
R4535 DGND.n389 DGND.n386 6.9214
R4536 DGND.n1012 DGND.n15 6.77697
R4537 DGND.n1010 DGND.n17 6.77697
R4538 DGND.n1005 DGND.n19 6.77697
R4539 DGND.n801 DGND.n797 6.77697
R4540 DGND.n930 DGND.n835 6.77697
R4541 DGND.n879 DGND.n863 6.77697
R4542 DGND.n874 DGND.n865 6.77697
R4543 DGND.n978 DGND.n789 6.77697
R4544 DGND.n776 DGND.n711 6.77697
R4545 DGND.n757 DGND.n723 6.77697
R4546 DGND.n1097 DGND.n1096 6.77697
R4547 DGND.n1161 DGND.n1104 6.77697
R4548 DGND.n691 DGND.n690 6.77697
R4549 DGND.n504 DGND.n503 6.77697
R4550 DGND.n670 DGND.n669 6.77697
R4551 DGND.n634 DGND.n633 6.77697
R4552 DGND.n632 DGND.n631 6.77697
R4553 DGND.n677 DGND.n676 6.77697
R4554 DGND.n414 DGND.n379 6.77697
R4555 DGND.n488 DGND.n48 6.77697
R4556 DGND.n107 DGND.n95 6.77697
R4557 DGND.n105 DGND.n97 6.77697
R4558 DGND.n164 DGND.n163 6.77697
R4559 DGND.n340 DGND.n287 6.77697
R4560 DGND.n325 DGND.n324 6.77697
R4561 DGND.n235 DGND.n229 6.77697
R4562 DGND.n188 DGND.n176 6.77697
R4563 DGND.n214 DGND.n213 6.77697
R4564 DGND.n1027 DGND.n1026 6.77697
R4565 DGND.n1066 DGND.n1065 6.77697
R4566 DGND.n982 DGND.n27 6.74974
R4567 DGND.n386 DGND.n385 6.37065
R4568 DGND.n35 DGND.n33 6.23872
R4569 DGND.n268 DGND.n267 5.91717
R4570 DGND.n1022 DGND.n2 5.91717
R4571 DGND.n992 DGND.n991 5.64756
R4572 DGND.n805 DGND.n804 5.64756
R4573 DGND.n945 DGND.n828 5.64756
R4574 DGND.n939 DGND.n832 5.64756
R4575 DGND.n845 DGND.n843 5.64756
R4576 DGND.n894 DGND.n856 5.64756
R4577 DGND.n888 DGND.n860 5.64756
R4578 DGND.n770 DGND.n769 5.64756
R4579 DGND.n754 DGND.n726 5.64756
R4580 DGND.n1174 DGND.n1173 5.64756
R4581 DGND.n515 DGND.n498 5.64756
R4582 DGND.n646 DGND.n525 5.64756
R4583 DGND.n562 DGND.n560 5.64756
R4584 DGND.n478 DGND.n54 5.64756
R4585 DGND.n60 DGND.n58 5.64756
R4586 DGND.n127 DGND.n126 5.64756
R4587 DGND.n164 DGND.n76 5.64756
R4588 DGND.n320 DGND.n319 5.64756
R4589 DGND.n247 DGND.n246 5.64756
R4590 DGND.n200 DGND.n199 5.64756
R4591 DGND.n1078 DGND.n1034 5.64756
R4592 DGND.n1053 DGND.n1044 5.64756
R4593 DGND.n941 DGND.n940 5.27109
R4594 DGND.n890 DGND.n889 5.27109
R4595 DGND.n706 DGND.n704 5.27109
R4596 DGND.n692 DGND.n689 5.06998
R4597 DGND.n799 DGND.n798 4.90477
R4598 DGND.n473 DGND.n472 4.51815
R4599 DGND.n836 DGND.n2 4.5005
R4600 DGND.n1184 DGND.n1183 4.5005
R4601 DGND DGND.n1 4.5005
R4602 DGND.n67 DGND.n0 4.5005
R4603 DGND.n269 DGND.n268 4.5005
R4604 DGND.n968 DGND.n817 4.35795
R4605 DGND.n993 DGND.n992 4.14168
R4606 DGND.n804 DGND.n794 4.14168
R4607 DGND.n942 DGND.n828 4.14168
R4608 DGND.n936 DGND.n832 4.14168
R4609 DGND.n913 DGND.n845 4.14168
R4610 DGND.n891 DGND.n856 4.14168
R4611 DGND.n885 DGND.n860 4.14168
R4612 DGND.n769 DGND.n768 4.14168
R4613 DGND.n751 DGND.n726 4.14168
R4614 DGND.n1173 DGND.n1172 4.14168
R4615 DGND.n671 DGND.n515 4.14168
R4616 DGND.n647 DGND.n646 4.14168
R4617 DGND.n643 DGND.n525 4.14168
R4618 DGND.n577 DGND.n562 4.14168
R4619 DGND.n475 DGND.n54 4.14168
R4620 DGND.n467 DGND.n60 4.14168
R4621 DGND.n465 DGND.n464 4.14168
R4622 DGND.n128 DGND.n127 4.14168
R4623 DGND.n167 DGND.n76 4.14168
R4624 DGND.n319 DGND.n318 4.14168
R4625 DGND.n246 DGND.n245 4.14168
R4626 DGND.n199 DGND.n198 4.14168
R4627 DGND.n1075 DGND.n1034 4.14168
R4628 DGND.n1050 DGND.n1044 4.14168
R4629 DGND.n648 DGND.n647 3.76521
R4630 DGND.n1002 DGND.n19 3.01226
R4631 DGND.n933 DGND.n835 3.01226
R4632 DGND.n882 DGND.n863 3.01226
R4633 DGND.n877 DGND.n865 3.01226
R4634 DGND.n978 DGND.n977 3.01226
R4635 DGND.n779 DGND.n711 3.01226
R4636 DGND.n723 DGND.n721 3.01226
R4637 DGND.n1104 DGND.n1102 3.01226
R4638 DGND.n635 DGND.n634 3.01226
R4639 DGND.n633 DGND.n632 3.01226
R4640 DGND.n568 DGND.n567 3.01226
R4641 DGND.n379 DGND.n377 3.01226
R4642 DGND.n48 DGND.n30 3.01226
R4643 DGND.n287 DGND.n285 3.01226
R4644 DGND.n326 DGND.n325 3.01226
R4645 DGND.n229 DGND.n227 3.01226
R4646 DGND.n189 DGND.n188 3.01226
R4647 DGND.n1067 DGND.n1066 3.01226
R4648 DGND.n995 DGND.n21 2.63579
R4649 DGND.n940 DGND.n939 2.63579
R4650 DGND.n934 DGND.n933 2.63579
R4651 DGND.n889 DGND.n888 2.63579
R4652 DGND.n883 DGND.n882 2.63579
R4653 DGND.n782 DGND.n682 2.63579
R4654 DGND.n748 DGND.n747 2.63579
R4655 DGND.n1130 DGND.n1129 2.63579
R4656 DGND.n668 DGND.n667 2.63579
R4657 DGND.n642 DGND.n641 2.63579
R4658 DGND.n640 DGND.n639 2.63579
R4659 DGND.n611 DGND.n610 2.63579
R4660 DGND.n604 DGND.n603 2.63579
R4661 DGND.n598 DGND.n553 2.63579
R4662 DGND.n390 DGND.n388 2.63579
R4663 DGND.n396 DGND.n395 2.63579
R4664 DGND.n405 DGND.n403 2.63579
R4665 DGND.n433 DGND.n432 2.63579
R4666 DGND.n426 DGND.n425 2.63579
R4667 DGND.n44 DGND.n43 2.63579
R4668 DGND.n132 DGND.n88 2.63579
R4669 DGND.n156 DGND.n155 2.63579
R4670 DGND.n171 DGND.n170 2.63579
R4671 DGND.n314 DGND.n299 2.63579
R4672 DGND.n241 DGND.n225 2.63579
R4673 DGND.n194 DGND.n187 2.63579
R4674 DGND.n1073 DGND.n1072 2.63579
R4675 DGND.n871 DGND.n870 2.57737
R4676 DGND.n566 DGND.n565 2.26105
R4677 DGND.n926 DGND.n837 1.88285
R4678 DGND.n902 DGND.n852 1.88285
R4679 DGND.n742 DGND.n741 1.88285
R4680 DGND.n1145 DGND.n1144 1.88285
R4681 DGND.n694 DGND.n688 1.88285
R4682 DGND.n617 DGND.n616 1.88285
R4683 DGND.n411 DGND.n410 1.88285
R4684 DGND.n439 DGND.n438 1.88285
R4685 DGND.n420 DGND.n376 1.88285
R4686 DGND.n137 DGND.n85 1.88285
R4687 DGND.n152 DGND.n80 1.88285
R4688 DGND.n273 DGND.n272 1.88285
R4689 DGND.n346 DGND.n284 1.88285
R4690 DGND.n332 DGND.n331 1.88285
R4691 DGND.n968 DGND.n967 1.8161
R4692 DGND.n268 DGND.n0 1.41717
R4693 DGND DGND.n0 1.41717
R4694 DGND DGND.n1184 1.41717
R4695 DGND.n1184 DGND.n2 1.41717
R4696 DGND.n480 DGND.n479 1.12991
R4697 DGND.n163 DGND.n162 1.12991
R4698 DGND.n812 DGND.n811 0.753441
R4699 DGND.n910 DGND.n848 0.753441
R4700 DGND.n872 DGND.n868 0.753441
R4701 DGND.n771 DGND.n716 0.753441
R4702 DGND.n765 DGND.n717 0.753441
R4703 DGND.n1169 DGND.n1098 0.753441
R4704 DGND.n1158 DGND.n1157 0.753441
R4705 DGND.n1151 DGND.n1150 0.753441
R4706 DGND.n1137 DGND.n1136 0.753441
R4707 DGND.n1132 DGND.n1118 0.753441
R4708 DGND.n701 DGND.n700 0.753441
R4709 DGND.n662 DGND.n661 0.753441
R4710 DGND.n593 DGND.n554 0.753441
R4711 DGND.n582 DGND.n581 0.753441
R4712 DGND.n576 DGND.n575 0.753441
R4713 DGND.n458 DGND.n457 0.753441
R4714 DGND.n37 DGND.n36 0.753441
R4715 DGND.n147 DGND.n146 0.753441
R4716 DGND.n351 DGND.n350 0.753441
R4717 DGND.n335 DGND.n291 0.753441
R4718 DGND.n502 DGND.n501 0.445597
R4719 DGND.n391 DGND.n386 0.376356
R4720 DGND.n983 DGND.n982 0.358046
R4721 DGND.n800 DGND.n799 0.243681
R4722 DGND.n232 DGND.n231 0.225854
R4723 DGND.n1047 DGND.n1045 0.178704
R4724 DGND.n38 DGND.n33 0.171355
R4725 DGND.n215 DGND.n179 0.147188
R4726 DGND.n104 DGND.n103 0.147003
R4727 DGND.n310 DGND.n309 0.146169
R4728 DGND.n800 DGND.n795 0.120292
R4729 DGND.n806 DGND.n795 0.120292
R4730 DGND.n807 DGND.n806 0.120292
R4731 DGND.n808 DGND.n807 0.120292
R4732 DGND.n808 DGND.n791 0.120292
R4733 DGND.n814 DGND.n791 0.120292
R4734 DGND.n815 DGND.n814 0.120292
R4735 DGND.n976 DGND.n815 0.120292
R4736 DGND.n976 DGND.n975 0.120292
R4737 DGND.n975 DGND.n974 0.120292
R4738 DGND.n974 DGND.n816 0.120292
R4739 DGND.n970 DGND.n816 0.120292
R4740 DGND.n970 DGND.n969 0.120292
R4741 DGND.n969 DGND.n818 0.120292
R4742 DGND.n962 DGND.n818 0.120292
R4743 DGND.n962 DGND.n961 0.120292
R4744 DGND.n961 DGND.n960 0.120292
R4745 DGND.n960 DGND.n821 0.120292
R4746 DGND.n956 DGND.n821 0.120292
R4747 DGND.n956 DGND.n955 0.120292
R4748 DGND.n955 DGND.n954 0.120292
R4749 DGND.n954 DGND.n824 0.120292
R4750 DGND.n950 DGND.n824 0.120292
R4751 DGND.n950 DGND.n949 0.120292
R4752 DGND.n949 DGND.n948 0.120292
R4753 DGND.n948 DGND.n826 0.120292
R4754 DGND.n944 DGND.n826 0.120292
R4755 DGND.n944 DGND.n943 0.120292
R4756 DGND.n943 DGND.n829 0.120292
R4757 DGND.n938 DGND.n829 0.120292
R4758 DGND.n938 DGND.n937 0.120292
R4759 DGND.n937 DGND.n833 0.120292
R4760 DGND.n932 DGND.n833 0.120292
R4761 DGND.n932 DGND.n931 0.120292
R4762 DGND.n928 DGND.n927 0.120292
R4763 DGND.n927 DGND.n838 0.120292
R4764 DGND.n922 DGND.n838 0.120292
R4765 DGND.n922 DGND.n921 0.120292
R4766 DGND.n921 DGND.n841 0.120292
R4767 DGND.n916 DGND.n841 0.120292
R4768 DGND.n916 DGND.n915 0.120292
R4769 DGND.n915 DGND.n914 0.120292
R4770 DGND.n914 DGND.n844 0.120292
R4771 DGND.n909 DGND.n844 0.120292
R4772 DGND.n909 DGND.n908 0.120292
R4773 DGND.n908 DGND.n849 0.120292
R4774 DGND.n904 DGND.n849 0.120292
R4775 DGND.n904 DGND.n903 0.120292
R4776 DGND.n903 DGND.n851 0.120292
R4777 DGND.n899 DGND.n851 0.120292
R4778 DGND.n899 DGND.n898 0.120292
R4779 DGND.n898 DGND.n897 0.120292
R4780 DGND.n897 DGND.n854 0.120292
R4781 DGND.n893 DGND.n854 0.120292
R4782 DGND.n893 DGND.n892 0.120292
R4783 DGND.n892 DGND.n857 0.120292
R4784 DGND.n887 DGND.n857 0.120292
R4785 DGND.n887 DGND.n886 0.120292
R4786 DGND.n886 DGND.n861 0.120292
R4787 DGND.n881 DGND.n861 0.120292
R4788 DGND.n881 DGND.n880 0.120292
R4789 DGND.n880 DGND.n864 0.120292
R4790 DGND.n876 DGND.n864 0.120292
R4791 DGND.n876 DGND.n875 0.120292
R4792 DGND.n875 DGND.n866 0.120292
R4793 DGND.n871 DGND.n866 0.120292
R4794 DGND.n693 DGND.n692 0.120292
R4795 DGND.n693 DGND.n687 0.120292
R4796 DGND.n697 DGND.n687 0.120292
R4797 DGND.n698 DGND.n697 0.120292
R4798 DGND.n699 DGND.n698 0.120292
R4799 DGND.n699 DGND.n683 0.120292
R4800 DGND.n707 DGND.n683 0.120292
R4801 DGND.n708 DGND.n707 0.120292
R4802 DGND.n784 DGND.n708 0.120292
R4803 DGND.n784 DGND.n783 0.120292
R4804 DGND.n783 DGND.n709 0.120292
R4805 DGND.n710 DGND.n709 0.120292
R4806 DGND.n778 DGND.n710 0.120292
R4807 DGND.n778 DGND.n777 0.120292
R4808 DGND.n777 DGND.n712 0.120292
R4809 DGND.n773 DGND.n712 0.120292
R4810 DGND.n773 DGND.n772 0.120292
R4811 DGND.n772 DGND.n715 0.120292
R4812 DGND.n767 DGND.n715 0.120292
R4813 DGND.n767 DGND.n766 0.120292
R4814 DGND.n766 DGND.n718 0.120292
R4815 DGND.n720 DGND.n718 0.120292
R4816 DGND.n760 DGND.n720 0.120292
R4817 DGND.n760 DGND.n759 0.120292
R4818 DGND.n759 DGND.n758 0.120292
R4819 DGND.n758 DGND.n722 0.120292
R4820 DGND.n725 DGND.n722 0.120292
R4821 DGND.n753 DGND.n725 0.120292
R4822 DGND.n753 DGND.n752 0.120292
R4823 DGND.n752 DGND.n727 0.120292
R4824 DGND.n746 DGND.n727 0.120292
R4825 DGND.n746 DGND.n745 0.120292
R4826 DGND.n745 DGND.n740 0.120292
R4827 DGND.n740 DGND.n3 0.120292
R4828 DGND.n1182 DGND.n4 0.120292
R4829 DGND.n1178 DGND.n4 0.120292
R4830 DGND.n1178 DGND.n1177 0.120292
R4831 DGND.n1177 DGND.n1176 0.120292
R4832 DGND.n1176 DGND.n7 0.120292
R4833 DGND.n1171 DGND.n7 0.120292
R4834 DGND.n1171 DGND.n1170 0.120292
R4835 DGND.n1170 DGND.n1099 0.120292
R4836 DGND.n1101 DGND.n1099 0.120292
R4837 DGND.n1164 DGND.n1101 0.120292
R4838 DGND.n1164 DGND.n1163 0.120292
R4839 DGND.n1163 DGND.n1162 0.120292
R4840 DGND.n1162 DGND.n1103 0.120292
R4841 DGND.n1106 DGND.n1103 0.120292
R4842 DGND.n1156 DGND.n1106 0.120292
R4843 DGND.n1156 DGND.n1155 0.120292
R4844 DGND.n1155 DGND.n1108 0.120292
R4845 DGND.n1149 DGND.n1108 0.120292
R4846 DGND.n1149 DGND.n1148 0.120292
R4847 DGND.n1148 DGND.n1147 0.120292
R4848 DGND.n1147 DGND.n1111 0.120292
R4849 DGND.n1141 DGND.n1111 0.120292
R4850 DGND.n1141 DGND.n1140 0.120292
R4851 DGND.n1140 DGND.n1139 0.120292
R4852 DGND.n1139 DGND.n1113 0.120292
R4853 DGND.n1114 DGND.n1113 0.120292
R4854 DGND.n1134 DGND.n1114 0.120292
R4855 DGND.n1134 DGND.n1133 0.120292
R4856 DGND.n1133 DGND.n1117 0.120292
R4857 DGND.n1128 DGND.n1117 0.120292
R4858 DGND.n1128 DGND.n1127 0.120292
R4859 DGND.n1127 DGND.n1126 0.120292
R4860 DGND.n1126 DGND.n1121 0.120292
R4861 DGND.n506 DGND.n501 0.120292
R4862 DGND.n507 DGND.n506 0.120292
R4863 DGND.n508 DGND.n507 0.120292
R4864 DGND.n508 DGND.n499 0.120292
R4865 DGND.n512 DGND.n499 0.120292
R4866 DGND.n513 DGND.n512 0.120292
R4867 DGND.n674 DGND.n513 0.120292
R4868 DGND.n674 DGND.n673 0.120292
R4869 DGND.n673 DGND.n672 0.120292
R4870 DGND.n672 DGND.n514 0.120292
R4871 DGND.n666 DGND.n514 0.120292
R4872 DGND.n666 DGND.n665 0.120292
R4873 DGND.n665 DGND.n664 0.120292
R4874 DGND.n664 DGND.n518 0.120292
R4875 DGND.n658 DGND.n518 0.120292
R4876 DGND.n658 DGND.n657 0.120292
R4877 DGND.n657 DGND.n656 0.120292
R4878 DGND.n656 DGND.n520 0.120292
R4879 DGND.n652 DGND.n520 0.120292
R4880 DGND.n652 DGND.n651 0.120292
R4881 DGND.n651 DGND.n650 0.120292
R4882 DGND.n650 DGND.n522 0.120292
R4883 DGND.n645 DGND.n522 0.120292
R4884 DGND.n645 DGND.n644 0.120292
R4885 DGND.n644 DGND.n526 0.120292
R4886 DGND.n638 DGND.n526 0.120292
R4887 DGND.n638 DGND.n637 0.120292
R4888 DGND.n637 DGND.n636 0.120292
R4889 DGND.n636 DGND.n530 0.120292
R4890 DGND.n630 DGND.n530 0.120292
R4891 DGND.n630 DGND.n629 0.120292
R4892 DGND.n629 DGND.n537 0.120292
R4893 DGND.n624 DGND.n538 0.120292
R4894 DGND.n624 DGND.n623 0.120292
R4895 DGND.n623 DGND.n622 0.120292
R4896 DGND.n622 DGND.n540 0.120292
R4897 DGND.n542 DGND.n540 0.120292
R4898 DGND.n615 DGND.n542 0.120292
R4899 DGND.n615 DGND.n614 0.120292
R4900 DGND.n614 DGND.n545 0.120292
R4901 DGND.n609 DGND.n545 0.120292
R4902 DGND.n609 DGND.n608 0.120292
R4903 DGND.n608 DGND.n607 0.120292
R4904 DGND.n607 DGND.n548 0.120292
R4905 DGND.n601 DGND.n548 0.120292
R4906 DGND.n601 DGND.n600 0.120292
R4907 DGND.n600 DGND.n599 0.120292
R4908 DGND.n599 DGND.n551 0.120292
R4909 DGND.n595 DGND.n551 0.120292
R4910 DGND.n595 DGND.n594 0.120292
R4911 DGND.n594 DGND.n555 0.120292
R4912 DGND.n556 DGND.n555 0.120292
R4913 DGND.n588 DGND.n556 0.120292
R4914 DGND.n588 DGND.n587 0.120292
R4915 DGND.n587 DGND.n586 0.120292
R4916 DGND.n586 DGND.n558 0.120292
R4917 DGND.n580 DGND.n558 0.120292
R4918 DGND.n580 DGND.n579 0.120292
R4919 DGND.n579 DGND.n578 0.120292
R4920 DGND.n578 DGND.n561 0.120292
R4921 DGND.n572 DGND.n561 0.120292
R4922 DGND.n572 DGND.n571 0.120292
R4923 DGND.n571 DGND.n570 0.120292
R4924 DGND.n570 DGND.n565 0.120292
R4925 DGND.n39 DGND.n38 0.120292
R4926 DGND.n39 DGND.n31 0.120292
R4927 DGND.n45 DGND.n31 0.120292
R4928 DGND.n46 DGND.n45 0.120292
R4929 DGND.n491 DGND.n46 0.120292
R4930 DGND.n491 DGND.n490 0.120292
R4931 DGND.n490 DGND.n489 0.120292
R4932 DGND.n489 DGND.n47 0.120292
R4933 DGND.n49 DGND.n47 0.120292
R4934 DGND.n484 DGND.n49 0.120292
R4935 DGND.n484 DGND.n483 0.120292
R4936 DGND.n483 DGND.n482 0.120292
R4937 DGND.n482 DGND.n51 0.120292
R4938 DGND.n53 DGND.n51 0.120292
R4939 DGND.n477 DGND.n53 0.120292
R4940 DGND.n477 DGND.n476 0.120292
R4941 DGND.n476 DGND.n55 0.120292
R4942 DGND.n470 DGND.n55 0.120292
R4943 DGND.n470 DGND.n469 0.120292
R4944 DGND.n469 DGND.n468 0.120292
R4945 DGND.n468 DGND.n59 0.120292
R4946 DGND.n462 DGND.n59 0.120292
R4947 DGND.n462 DGND.n461 0.120292
R4948 DGND.n461 DGND.n460 0.120292
R4949 DGND.n460 DGND.n63 0.120292
R4950 DGND.n454 DGND.n63 0.120292
R4951 DGND.n454 DGND.n453 0.120292
R4952 DGND.n453 DGND.n452 0.120292
R4953 DGND.n452 DGND.n65 0.120292
R4954 DGND.n66 DGND.n65 0.120292
R4955 DGND.n446 DGND.n68 0.120292
R4956 DGND.n446 DGND.n445 0.120292
R4957 DGND.n445 DGND.n444 0.120292
R4958 DGND.n444 DGND.n70 0.120292
R4959 DGND.n364 DGND.n70 0.120292
R4960 DGND.n437 DGND.n364 0.120292
R4961 DGND.n437 DGND.n436 0.120292
R4962 DGND.n436 DGND.n367 0.120292
R4963 DGND.n431 DGND.n367 0.120292
R4964 DGND.n431 DGND.n430 0.120292
R4965 DGND.n430 DGND.n429 0.120292
R4966 DGND.n429 DGND.n370 0.120292
R4967 DGND.n423 DGND.n370 0.120292
R4968 DGND.n423 DGND.n422 0.120292
R4969 DGND.n422 DGND.n421 0.120292
R4970 DGND.n421 DGND.n373 0.120292
R4971 DGND.n417 DGND.n373 0.120292
R4972 DGND.n417 DGND.n416 0.120292
R4973 DGND.n416 DGND.n415 0.120292
R4974 DGND.n415 DGND.n378 0.120292
R4975 DGND.n409 DGND.n378 0.120292
R4976 DGND.n409 DGND.n408 0.120292
R4977 DGND.n408 DGND.n381 0.120292
R4978 DGND.n402 DGND.n381 0.120292
R4979 DGND.n402 DGND.n401 0.120292
R4980 DGND.n401 DGND.n400 0.120292
R4981 DGND.n400 DGND.n383 0.120292
R4982 DGND.n393 DGND.n383 0.120292
R4983 DGND.n393 DGND.n392 0.120292
R4984 DGND.n392 DGND.n391 0.120292
R4985 DGND.n104 DGND.n96 0.120292
R4986 DGND.n109 DGND.n96 0.120292
R4987 DGND.n110 DGND.n109 0.120292
R4988 DGND.n111 DGND.n110 0.120292
R4989 DGND.n111 DGND.n94 0.120292
R4990 DGND.n115 DGND.n94 0.120292
R4991 DGND.n116 DGND.n115 0.120292
R4992 DGND.n117 DGND.n116 0.120292
R4993 DGND.n117 DGND.n92 0.120292
R4994 DGND.n123 DGND.n92 0.120292
R4995 DGND.n124 DGND.n123 0.120292
R4996 DGND.n125 DGND.n124 0.120292
R4997 DGND.n125 DGND.n89 0.120292
R4998 DGND.n130 DGND.n89 0.120292
R4999 DGND.n131 DGND.n130 0.120292
R5000 DGND.n131 DGND.n86 0.120292
R5001 DGND.n135 DGND.n86 0.120292
R5002 DGND.n136 DGND.n135 0.120292
R5003 DGND.n136 DGND.n84 0.120292
R5004 DGND.n141 DGND.n84 0.120292
R5005 DGND.n142 DGND.n141 0.120292
R5006 DGND.n143 DGND.n142 0.120292
R5007 DGND.n143 DGND.n81 0.120292
R5008 DGND.n150 DGND.n81 0.120292
R5009 DGND.n151 DGND.n150 0.120292
R5010 DGND.n151 DGND.n79 0.120292
R5011 DGND.n157 DGND.n79 0.120292
R5012 DGND.n158 DGND.n157 0.120292
R5013 DGND.n159 DGND.n158 0.120292
R5014 DGND.n159 DGND.n77 0.120292
R5015 DGND.n165 DGND.n77 0.120292
R5016 DGND.n166 DGND.n165 0.120292
R5017 DGND.n166 DGND.n75 0.120292
R5018 DGND.n172 DGND.n75 0.120292
R5019 DGND.n173 DGND.n172 0.120292
R5020 DGND.n270 DGND.n73 0.120292
R5021 DGND.n276 DGND.n73 0.120292
R5022 DGND.n277 DGND.n276 0.120292
R5023 DGND.n357 DGND.n277 0.120292
R5024 DGND.n357 DGND.n356 0.120292
R5025 DGND.n356 DGND.n355 0.120292
R5026 DGND.n355 DGND.n278 0.120292
R5027 DGND.n349 DGND.n278 0.120292
R5028 DGND.n349 DGND.n348 0.120292
R5029 DGND.n348 DGND.n347 0.120292
R5030 DGND.n347 DGND.n281 0.120292
R5031 DGND.n343 DGND.n281 0.120292
R5032 DGND.n343 DGND.n342 0.120292
R5033 DGND.n342 DGND.n341 0.120292
R5034 DGND.n341 DGND.n286 0.120292
R5035 DGND.n337 DGND.n286 0.120292
R5036 DGND.n337 DGND.n336 0.120292
R5037 DGND.n336 DGND.n290 0.120292
R5038 DGND.n330 DGND.n290 0.120292
R5039 DGND.n330 DGND.n329 0.120292
R5040 DGND.n329 DGND.n328 0.120292
R5041 DGND.n328 DGND.n294 0.120292
R5042 DGND.n323 DGND.n294 0.120292
R5043 DGND.n323 DGND.n322 0.120292
R5044 DGND.n322 DGND.n321 0.120292
R5045 DGND.n321 DGND.n297 0.120292
R5046 DGND.n316 DGND.n297 0.120292
R5047 DGND.n316 DGND.n315 0.120292
R5048 DGND.n315 DGND.n300 0.120292
R5049 DGND.n311 DGND.n300 0.120292
R5050 DGND.n311 DGND.n310 0.120292
R5051 DGND.n211 DGND.n179 0.120292
R5052 DGND.n211 DGND.n210 0.120292
R5053 DGND.n210 DGND.n209 0.120292
R5054 DGND.n209 DGND.n181 0.120292
R5055 DGND.n205 DGND.n181 0.120292
R5056 DGND.n205 DGND.n204 0.120292
R5057 DGND.n204 DGND.n203 0.120292
R5058 DGND.n203 DGND.n183 0.120292
R5059 DGND.n197 DGND.n183 0.120292
R5060 DGND.n197 DGND.n196 0.120292
R5061 DGND.n196 DGND.n195 0.120292
R5062 DGND.n195 DGND.n185 0.120292
R5063 DGND.n191 DGND.n185 0.120292
R5064 DGND.n191 DGND.n190 0.120292
R5065 DGND.n190 DGND.n174 0.120292
R5066 DGND.n266 DGND.n175 0.120292
R5067 DGND.n262 DGND.n175 0.120292
R5068 DGND.n262 DGND.n261 0.120292
R5069 DGND.n261 DGND.n260 0.120292
R5070 DGND.n260 DGND.n178 0.120292
R5071 DGND.n256 DGND.n178 0.120292
R5072 DGND.n256 DGND.n255 0.120292
R5073 DGND.n255 DGND.n254 0.120292
R5074 DGND.n254 DGND.n220 0.120292
R5075 DGND.n250 DGND.n220 0.120292
R5076 DGND.n250 DGND.n249 0.120292
R5077 DGND.n249 DGND.n248 0.120292
R5078 DGND.n248 DGND.n223 0.120292
R5079 DGND.n243 DGND.n223 0.120292
R5080 DGND.n243 DGND.n242 0.120292
R5081 DGND.n242 DGND.n226 0.120292
R5082 DGND.n238 DGND.n226 0.120292
R5083 DGND.n238 DGND.n237 0.120292
R5084 DGND.n237 DGND.n236 0.120292
R5085 DGND.n236 DGND.n228 0.120292
R5086 DGND.n232 DGND.n228 0.120292
R5087 DGND.n984 DGND.n983 0.120292
R5088 DGND.n984 DGND.n25 0.120292
R5089 DGND.n988 DGND.n25 0.120292
R5090 DGND.n989 DGND.n988 0.120292
R5091 DGND.n990 DGND.n989 0.120292
R5092 DGND.n990 DGND.n22 0.120292
R5093 DGND.n997 DGND.n22 0.120292
R5094 DGND.n998 DGND.n997 0.120292
R5095 DGND.n999 DGND.n998 0.120292
R5096 DGND.n999 DGND.n20 0.120292
R5097 DGND.n1003 DGND.n20 0.120292
R5098 DGND.n1004 DGND.n1003 0.120292
R5099 DGND.n1004 DGND.n18 0.120292
R5100 DGND.n1008 DGND.n18 0.120292
R5101 DGND.n1009 DGND.n1008 0.120292
R5102 DGND.n1009 DGND.n16 0.120292
R5103 DGND.n1014 DGND.n16 0.120292
R5104 DGND.n1015 DGND.n1014 0.120292
R5105 DGND.n1016 DGND.n1015 0.120292
R5106 DGND.n1016 DGND.n14 0.120292
R5107 DGND.n1020 DGND.n14 0.120292
R5108 DGND.n1021 DGND.n1020 0.120292
R5109 DGND.n1023 DGND.n12 0.120292
R5110 DGND.n1028 DGND.n12 0.120292
R5111 DGND.n1029 DGND.n1028 0.120292
R5112 DGND.n1089 DGND.n1029 0.120292
R5113 DGND.n1089 DGND.n1088 0.120292
R5114 DGND.n1088 DGND.n1087 0.120292
R5115 DGND.n1087 DGND.n1030 0.120292
R5116 DGND.n1083 DGND.n1030 0.120292
R5117 DGND.n1083 DGND.n1082 0.120292
R5118 DGND.n1082 DGND.n1081 0.120292
R5119 DGND.n1081 DGND.n1032 0.120292
R5120 DGND.n1077 DGND.n1032 0.120292
R5121 DGND.n1077 DGND.n1076 0.120292
R5122 DGND.n1076 DGND.n1035 0.120292
R5123 DGND.n1071 DGND.n1035 0.120292
R5124 DGND.n1071 DGND.n1070 0.120292
R5125 DGND.n1070 DGND.n1069 0.120292
R5126 DGND.n1069 DGND.n1038 0.120292
R5127 DGND.n1064 DGND.n1038 0.120292
R5128 DGND.n1064 DGND.n1063 0.120292
R5129 DGND.n1063 DGND.n1062 0.120292
R5130 DGND.n1062 DGND.n1040 0.120292
R5131 DGND.n1058 DGND.n1040 0.120292
R5132 DGND.n1058 DGND.n1057 0.120292
R5133 DGND.n1057 DGND.n1056 0.120292
R5134 DGND.n1056 DGND.n1042 0.120292
R5135 DGND.n1052 DGND.n1042 0.120292
R5136 DGND.n1052 DGND.n1051 0.120292
R5137 DGND.n1051 DGND.n1045 0.120292
R5138 DGND.n931 DGND.n836 0.0864375
R5139 DGND.n1183 DGND.n3 0.0864375
R5140 DGND.n537 DGND.n1 0.0864375
R5141 DGND.n67 DGND.n66 0.0864375
R5142 DGND.n269 DGND.n173 0.0864375
R5143 DGND.n267 DGND.n174 0.0864375
R5144 DGND.n1022 DGND.n1021 0.0864375
R5145 DGND.n928 DGND.n836 0.0343542
R5146 DGND.n1183 DGND.n1182 0.0343542
R5147 DGND.n538 DGND.n1 0.0343542
R5148 DGND.n68 DGND.n67 0.0343542
R5149 DGND.n270 DGND.n269 0.0343542
R5150 DGND.n267 DGND.n266 0.0343542
R5151 DGND.n1023 DGND.n1022 0.0343542
R5152 a_1697_6807.n6 a_1697_6807.n1 614.178
R5153 a_1697_6807.n7 a_1697_6807.n6 409.844
R5154 a_1697_6807.n5 a_1697_6807.t7 373.283
R5155 a_1697_6807.n2 a_1697_6807.t8 347.577
R5156 a_1697_6807.n3 a_1697_6807.t6 334.723
R5157 a_1697_6807.n4 a_1697_6807.t9 323.476
R5158 a_1697_6807.n4 a_1697_6807.t5 217.436
R5159 a_1697_6807.n3 a_1697_6807.t10 206.19
R5160 a_1697_6807.n2 a_1697_6807.t4 193.337
R5161 a_1697_6807.n0 a_1697_6807.n4 169.833
R5162 a_1697_6807.n0 a_1697_6807.n3 169.745
R5163 a_1697_6807.n5 a_1697_6807.t11 167.63
R5164 a_1697_6807.n0 a_1697_6807.n2 166.674
R5165 a_1697_6807.n0 a_1697_6807.n5 166.421
R5166 a_1697_6807.n1 a_1697_6807.t1 91.4648
R5167 a_1697_6807.n1 a_1697_6807.t3 63.3219
R5168 a_1697_6807.t0 a_1697_6807.n7 55.7148
R5169 a_1697_6807.n6 a_1697_6807.n0 42.2239
R5170 a_1697_6807.n7 a_1697_6807.t2 38.5719
R5171 a5.n1 a5.t4 230.155
R5172 a5.n0 a5.t0 230.155
R5173 a5.n5 a5.t8 230.155
R5174 a5.n3 a5.t6 230.155
R5175 a5.n8 a5.t9 230.155
R5176 a5.n10 a5.t11 230.155
R5177 a5.n1 a5.t10 157.856
R5178 a5.n0 a5.t5 157.856
R5179 a5.n5 a5.t2 157.856
R5180 a5.n3 a5.t1 157.856
R5181 a5.n8 a5.t3 157.856
R5182 a5.n10 a5.t7 157.856
R5183 a5.n4 a5.n3 153.147
R5184 a5 a5.n0 152
R5185 a5 a5.n5 152
R5186 a5 a5.n8 152
R5187 a5 a5.n10 152
R5188 a5 a5.n1 152
R5189 a5.n2 a5 34.1537
R5190 a5.n6 a5 24.6112
R5191 a5 a5.n9 23.005
R5192 a5.n9 a5 20.802
R5193 a5.n6 a5.n4 15.6579
R5194 a5.n2 a5 11.7925
R5195 a5.n7 a5.n2 10.8004
R5196 a5.n7 a5.n6 8.38818
R5197 a5.n9 a5.n7 1.0768
R5198 a5.n4 a5 0.38259
R5199 a_1775_5206.n2 a_1775_5206.t8 384.529
R5200 a_1775_5206.n1 a_1775_5206.t9 373.283
R5201 a_1775_5206.n4 a_1775_5206.t3 351.861
R5202 a_1775_5206.n3 a_1775_5206.t2 297.233
R5203 a_1775_5206.t1 a_1775_5206.n6 279.005
R5204 a_1775_5206.n5 a_1775_5206.n4 214.362
R5205 a_1775_5206.n0 a_1775_5206.n2 169.627
R5206 a_1775_5206.n0 a_1775_5206.n1 167.657
R5207 a_1775_5206.n1 a_1775_5206.t7 167.63
R5208 a_1775_5206.n0 a_1775_5206.n5 163.79
R5209 a_1775_5206.n2 a_1775_5206.t5 156.382
R5210 a_1775_5206.n6 a_1775_5206.t0 130.594
R5211 a_1775_5206.n4 a_1775_5206.t6 109.215
R5212 a_1775_5206.n3 a_1775_5206.t4 102.659
R5213 a_1775_5206.n5 a_1775_5206.n3 47.4474
R5214 a_1775_5206.n6 a_1775_5206.n0 39.5232
R5215 a2.n5 a2.t11 230.155
R5216 a2.n6 a2.t3 230.155
R5217 a2.n2 a2.t0 230.155
R5218 a2.n1 a2.t1 230.155
R5219 a2.n0 a2.t2 230.155
R5220 a2.n9 a2.t10 230.155
R5221 a2.n5 a2.t7 157.856
R5222 a2.n6 a2.t9 157.856
R5223 a2.n2 a2.t5 157.856
R5224 a2.n1 a2.t6 157.856
R5225 a2.n0 a2.t8 157.856
R5226 a2.n9 a2.t4 157.856
R5227 a2 a2.n6 152
R5228 a2 a2.n2 152
R5229 a2 a2.n1 152
R5230 a2 a2.n0 152
R5231 a2 a2.n9 152
R5232 a2 a2.n5 152
R5233 a2.n4 a2 29.8047
R5234 a2.n3 a2 18.4465
R5235 a2 a2.n8 17.3126
R5236 a2.n3 a2 16.1045
R5237 a2.n8 a2.n7 16.0417
R5238 a2.n7 a2 13.2004
R5239 a2.n7 a2 11.6045
R5240 a2.n4 a2.n3 4.93162
R5241 a2.n8 a2.n4 4.703
R5242 b1.n4 b1.t2 229.369
R5243 b1.n6 b1.t9 229.369
R5244 b1.n5 b1.t8 229.369
R5245 b1.n2 b1.t5 229.369
R5246 b1.n1 b1.t4 229.369
R5247 b1.n0 b1.t0 229.369
R5248 b1.n4 b1.t7 157.07
R5249 b1.n6 b1.t3 157.07
R5250 b1.n5 b1.t1 157.07
R5251 b1.n2 b1.t10 157.07
R5252 b1.n1 b1.t11 157.07
R5253 b1.n0 b1.t6 157.07
R5254 b1 b1.n6 152.238
R5255 b1 b1.n5 152.238
R5256 b1 b1.n2 152.238
R5257 b1 b1.n1 152.238
R5258 b1 b1.n0 152.238
R5259 b1 b1.n4 152.238
R5260 b1.n3 b1 31.1031
R5261 b1.n7 b1 25.0165
R5262 b1.n8 b1.n7 22.3725
R5263 b1.n8 b1 19.6861
R5264 b1 b1.n9 16.1367
R5265 b1.n7 b1 10.7227
R5266 b1.n3 b1 10.7227
R5267 b1.n9 b1.n3 8.14662
R5268 b1.n9 b1.n8 4.703
R5269 P7 P7.n0 817.516
R5270 P7 P7.n1 206.505
R5271 P7.n0 P7.t2 91.4648
R5272 P7.n0 P7.t0 63.3219
R5273 P7.n1 P7.t3 55.7148
R5274 P7.n1 P7.t1 38.5719
R5275 P1 P1.n0 817.516
R5276 P1 P1.n1 206.505
R5277 P1.n0 P1.t0 91.4648
R5278 P1.n0 P1.t2 63.3219
R5279 P1.n1 P1.t1 55.7148
R5280 P1.n1 P1.t3 38.5719
R5281 b3.n5 b3.t0 229.369
R5282 b3.n4 b3.t10 229.369
R5283 b3.n7 b3.t1 229.369
R5284 b3.n2 b3.t3 229.369
R5285 b3.n1 b3.t2 229.369
R5286 b3.n0 b3.t4 229.369
R5287 b3.n5 b3.t8 157.07
R5288 b3.n4 b3.t5 157.07
R5289 b3.n7 b3.t7 157.07
R5290 b3.n2 b3.t9 157.07
R5291 b3.n1 b3.t6 157.07
R5292 b3.n0 b3.t11 157.07
R5293 b3 b3.n5 153.147
R5294 b3 b3.n4 152.238
R5295 b3 b3.n7 152.238
R5296 b3 b3.n2 152.238
R5297 b3 b3.n1 152.238
R5298 b3 b3.n0 152.238
R5299 b3.n9 b3.n8 19.7313
R5300 b3.n3 b3 19.57
R5301 b3.n8 b3 15.5168
R5302 b3.n3 b3 15.2227
R5303 b3.n8 b3.n6 14.8056
R5304 b3.n6 b3 11.5936
R5305 b3 b3.n9 10.9107
R5306 b3.n6 b3 10.7227
R5307 b3.n9 b3.n3 7.65435
R5308 b2.n0 b2.t7 229.369
R5309 b2.n1 b2.t3 229.369
R5310 b2.n5 b2.t2 229.369
R5311 b2.n3 b2.t4 229.369
R5312 b2.n2 b2.t5 229.369
R5313 b2.n9 b2.t6 229.369
R5314 b2.n0 b2.t0 157.07
R5315 b2.n1 b2.t10 157.07
R5316 b2.n5 b2.t9 157.07
R5317 b2.n3 b2.t11 157.07
R5318 b2.n2 b2.t1 157.07
R5319 b2.n9 b2.t8 157.07
R5320 b2 b2.n1 152.238
R5321 b2 b2.n5 152.238
R5322 b2 b2.n3 152.238
R5323 b2 b2.n2 152.238
R5324 b2 b2.n0 152.238
R5325 b2.n10 b2.n9 152
R5326 b2.n10 b2.n8 31.7311
R5327 b2.n4 b2 21.2044
R5328 b2.n4 b2 21.1995
R5329 b2.n7 b2.n6 20.0775
R5330 b2.n8 b2 17.2517
R5331 b2.n7 b2 10.7227
R5332 b2.n6 b2 10.7227
R5333 b2.n6 b2.n4 9.82871
R5334 b2.n8 b2.n7 7.62653
R5335 b2 b2.n10 1.14677
R5336 b5.n6 b5.t7 229.369
R5337 b5.n1 b5.t1 229.369
R5338 b5.n3 b5.t3 229.369
R5339 b5.n2 b5.t10 229.369
R5340 b5.n8 b5.t4 229.369
R5341 b5.n0 b5.t8 229.369
R5342 b5.n6 b5.t0 157.07
R5343 b5.n1 b5.t6 157.07
R5344 b5.n3 b5.t9 157.07
R5345 b5.n2 b5.t5 157.07
R5346 b5.n8 b5.t11 157.07
R5347 b5.n0 b5.t2 157.07
R5348 b5 b5.n1 152.238
R5349 b5 b5.n3 152.238
R5350 b5 b5.n2 152.238
R5351 b5 b5.n8 152.238
R5352 b5 b5.n0 152.238
R5353 b5 b5.n6 152.238
R5354 b5.n4 b5 26.7019
R5355 b5.n9 b5 24.7833
R5356 b5.n4 b5 20.0278
R5357 b5.n5 b5 18.598
R5358 b5.n7 b5.n5 15.1392
R5359 b5 b5.n9 10.9107
R5360 b5.n7 b5 10.7227
R5361 b5.n9 b5.n7 1.40842
R5362 b5.n5 b5.n4 1.21805
R5363 a0.n2 a0.t2 230.155
R5364 a0.n1 a0.t8 230.155
R5365 a0.n0 a0.t6 230.155
R5366 a0.n5 a0.t9 230.155
R5367 a0.n7 a0.t11 230.155
R5368 a0.n9 a0.t7 230.155
R5369 a0.n2 a0.t10 157.856
R5370 a0.n1 a0.t3 157.856
R5371 a0.n0 a0.t1 157.856
R5372 a0.n5 a0.t4 157.856
R5373 a0.n7 a0.t5 157.856
R5374 a0.n9 a0.t0 157.856
R5375 a0 a0.n1 152
R5376 a0 a0.n0 152
R5377 a0 a0.n5 152
R5378 a0 a0.n7 152
R5379 a0 a0.n9 152
R5380 a0 a0.n2 152
R5381 a0.n3 a0 28.2824
R5382 a0.n8 a0 24.669
R5383 a0.n4 a0 24.6432
R5384 a0.n6 a0 22.544
R5385 a0 a0.n8 21.9831
R5386 a0.n3 a0 16.1045
R5387 a0.n4 a0.n3 6.14591
R5388 a0.n6 a0.n4 1.36507
R5389 a0.n8 a0.n6 0.8606
R5390 a1.n1 a1.t10 230.155
R5391 a1.n0 a1.t0 230.155
R5392 a1.n4 a1.t4 230.155
R5393 a1.n3 a1.t3 230.155
R5394 a1.n7 a1.t6 230.155
R5395 a1.n9 a1.t1 230.155
R5396 a1.n1 a1.t2 157.856
R5397 a1.n0 a1.t5 157.856
R5398 a1.n4 a1.t7 157.856
R5399 a1.n3 a1.t8 157.856
R5400 a1.n7 a1.t11 157.856
R5401 a1.n9 a1.t9 157.856
R5402 a1 a1.n0 152
R5403 a1 a1.n4 152
R5404 a1 a1.n3 152
R5405 a1 a1.n7 152
R5406 a1 a1.n9 152
R5407 a1 a1.n1 152
R5408 a1.n5 a1 28.5615
R5409 a1.n2 a1 23.3036
R5410 a1 a1.n8 22.7911
R5411 a1.n8 a1 19.8213
R5412 a1.n5 a1 16.1045
R5413 a1.n2 a1 16.1045
R5414 a1.n6 a1.n2 6.3791
R5415 a1.n6 a1.n5 5.84233
R5416 a1.n8 a1.n6 1.00473
R5417 a_2520_591.n2 a_2520_591.n0 793.865
R5418 a_2520_591.n1 a_2520_591.t5 230.576
R5419 a_2520_591.n3 a_2520_591.n2 226.488
R5420 a_2520_591.n2 a_2520_591.n1 207.751
R5421 a_2520_591.n1 a_2520_591.t4 158.275
R5422 a_2520_591.n0 a_2520_591.t0 91.4648
R5423 a_2520_591.n0 a_2520_591.t2 63.3219
R5424 a_2520_591.t1 a_2520_591.n3 55.7148
R5425 a_2520_591.n3 a_2520_591.t3 38.5719
R5426 P4.n0 P4.t1 277.849
R5427 P4.n0 P4.t0 131.749
R5428 P4 P4.n0 3.24162
R5429 a3.n6 a3.t8 230.155
R5430 a3.n4 a3.t7 230.155
R5431 a3.n2 a3.t1 230.155
R5432 a3.n1 a3.t0 230.155
R5433 a3.n0 a3.t3 230.155
R5434 a3.n9 a3.t10 230.155
R5435 a3.n6 a3.t2 157.856
R5436 a3.n4 a3.t4 157.856
R5437 a3.n2 a3.t9 157.856
R5438 a3.n1 a3.t6 157.856
R5439 a3.n0 a3.t11 157.856
R5440 a3.n9 a3.t5 157.856
R5441 a3 a3.n4 152
R5442 a3 a3.n2 152
R5443 a3 a3.n1 152
R5444 a3 a3.n0 152
R5445 a3 a3.n9 152
R5446 a3 a3.n6 152
R5447 a3.n3 a3 29.5054
R5448 a3.n8 a3 26.1306
R5449 a3.n5 a3 19.6514
R5450 a3.n5 a3.n3 14.0222
R5451 a3 a3.n8 13.0246
R5452 a3.n3 a3 11.8986
R5453 a3.n7 a3 11.6045
R5454 a3.n7 a3.n5 9.31896
R5455 a3.n8 a3.n7 0.188462
R5456 b4.n7 b4.t11 229.369
R5457 b4.n5 b4.t6 229.369
R5458 b4.n3 b4.t7 229.369
R5459 b4.n2 b4.t1 229.369
R5460 b4.n1 b4.t9 229.369
R5461 b4.n0 b4.t2 229.369
R5462 b4.n7 b4.t4 157.07
R5463 b4.n5 b4.t0 157.07
R5464 b4.n3 b4.t10 157.07
R5465 b4.n2 b4.t5 157.07
R5466 b4.n1 b4.t3 157.07
R5467 b4.n0 b4.t8 157.07
R5468 b4 b4.n5 152.238
R5469 b4 b4.n3 152.238
R5470 b4 b4.n2 152.238
R5471 b4 b4.n1 152.238
R5472 b4 b4.n0 152.238
R5473 b4 b4.n7 152.238
R5474 b4.n4 b4 22.4871
R5475 b4.n4 b4 17.9223
R5476 b4.n6 b4 16.0621
R5477 b4.n8 b4.n6 14.5091
R5478 b4 b4.n9 12.1428
R5479 b4.n9 b4 10.9107
R5480 b4.n8 b4 10.7227
R5481 b4.n6 b4.n4 6.85369
R5482 b4.n9 b4.n8 1.40842
R5483 a_395_5206.n2 a_395_5206.t8 384.529
R5484 a_395_5206.n1 a_395_5206.t7 373.283
R5485 a_395_5206.n4 a_395_5206.t10 351.861
R5486 a_395_5206.n3 a_395_5206.t9 297.233
R5487 a_395_5206.n5 a_395_5206.n4 214.362
R5488 a_395_5206.n6 a_395_5206.t1 199.456
R5489 a_395_5206.n7 a_395_5206.n6 190.911
R5490 a_395_5206.n0 a_395_5206.n2 169.627
R5491 a_395_5206.n0 a_395_5206.n1 167.657
R5492 a_395_5206.n1 a_395_5206.t5 167.63
R5493 a_395_5206.n0 a_395_5206.n5 163.79
R5494 a_395_5206.n2 a_395_5206.t6 156.382
R5495 a_395_5206.n4 a_395_5206.t4 109.215
R5496 a_395_5206.n3 a_395_5206.t3 102.659
R5497 a_395_5206.n5 a_395_5206.n3 47.4474
R5498 a_395_5206.n6 a_395_5206.n0 35.2975
R5499 a_395_5206.t0 a_395_5206.n7 26.5955
R5500 a_395_5206.n7 a_395_5206.t2 26.5955
R5501 P8.n0 P8.t1 277.849
R5502 P8.n0 P8.t0 131.749
R5503 P8 P8.n0 3.24162
R5504 P5 P5.n0 817.516
R5505 P5 P5.n1 206.505
R5506 P5.n0 P5.t3 91.4648
R5507 P5.n0 P5.t0 63.3219
R5508 P5.n1 P5.t2 55.7148
R5509 P5.n1 P5.t1 38.5719
R5510 P2.n0 P2.t1 277.849
R5511 P2.n0 P2.t0 131.749
R5512 P2 P2.n0 3.24162
R5513 b0.n6 b0.t4 229.369
R5514 b0.n4 b0.t8 229.369
R5515 b0.n2 b0.t6 229.369
R5516 b0.n1 b0.t2 229.369
R5517 b0.n8 b0.t5 229.369
R5518 b0.n0 b0.t1 229.369
R5519 b0.n6 b0.t9 157.07
R5520 b0.n4 b0.t3 157.07
R5521 b0.n2 b0.t0 157.07
R5522 b0.n1 b0.t7 157.07
R5523 b0.n8 b0.t11 157.07
R5524 b0.n0 b0.t10 157.07
R5525 b0 b0.n4 152.238
R5526 b0 b0.n2 152.238
R5527 b0 b0.n1 152.238
R5528 b0 b0.n8 152.238
R5529 b0 b0.n0 152.238
R5530 b0 b0.n6 152.238
R5531 b0.n3 b0 42.5948
R5532 b0 b0.n9 29.0235
R5533 b0.n3 b0 18.7086
R5534 b0.n9 b0.n7 16.6942
R5535 b0.n7 b0 15.5168
R5536 b0.n9 b0 15.2227
R5537 b0.n5 b0 10.7227
R5538 b0.n5 b0.n3 9.93555
R5539 b0.n7 b0.n5 9.33395
R5540 a_1697_5095.n5 a_1697_5095.t4 373.283
R5541 a_1697_5095.n1 a_1697_5095.t5 347.577
R5542 a_1697_5095.n2 a_1697_5095.t2 334.723
R5543 a_1697_5095.n3 a_1697_5095.t6 323.476
R5544 a_1697_5095.t1 a_1697_5095.n6 217.506
R5545 a_1697_5095.n3 a_1697_5095.t9 217.436
R5546 a_1697_5095.n2 a_1697_5095.t3 206.19
R5547 a_1697_5095.n1 a_1697_5095.t8 193.337
R5548 a_1697_5095.n6 a_1697_5095.t0 192.093
R5549 a_1697_5095.n4 a_1697_5095.n3 169.833
R5550 a_1697_5095.n4 a_1697_5095.n2 169.745
R5551 a_1697_5095.n5 a_1697_5095.t7 167.63
R5552 a_1697_5095.n0 a_1697_5095.n1 166.674
R5553 a_1697_5095.n0 a_1697_5095.n5 166.421
R5554 a_1697_5095.n6 a_1697_5095.n0 44.9992
R5555 a_1697_5095.n0 a_1697_5095.n4 1.64225
R5556 P11.n0 P11.t0 327.274
R5557 P11 P11.n2 201.189
R5558 P11.n1 P11.n0 185
R5559 P11.n2 P11.n1 92.3082
R5560 P11.n1 P11.t1 24.9236
R5561 P11.n2 P11.t2 24.9236
R5562 P11 P11.n0 21.4593
R5563 P9 P9.n0 817.516
R5564 P9 P9.n1 206.505
R5565 P9.n0 P9.t0 91.4648
R5566 P9.n0 P9.t2 63.3219
R5567 P9.n1 P9.t1 55.7148
R5568 P9.n1 P9.t3 38.5719
R5569 P0.n0 P0.t1 277.849
R5570 P0.n0 P0.t0 131.749
R5571 P0 P0.n0 3.24162
R5572 P10.n0 P10.t1 277.849
R5573 P10.n0 P10.t0 131.749
R5574 P10 P10.n0 3.24162
R5575 P3 P3.n0 817.516
R5576 P3 P3.n1 206.505
R5577 P3.n0 P3.t1 91.4648
R5578 P3.n0 P3.t3 63.3219
R5579 P3.n1 P3.t0 55.7148
R5580 P3.n1 P3.t2 38.5719
R5581 P6.n0 P6.t1 277.849
R5582 P6.n0 P6.t0 131.749
R5583 P6 P6.n0 3.24162
C0 a2 a_2263_5309# 7.25e-19
C1 a_4115_5853# a_4471_5853# 0.008475f
C2 a_1171_1679# a_1527_1679# 0.008475f
C3 a_2493_1929# a_2467_2223# 2.29e-19
C4 a_3941_5853# a_4351_5206# 2.79e-20
C5 a_2045_2223# a_2520_3855# 0.064835f
C6 DVDD a_4103_1135# 0.251014f
C7 a_1125_3017# a_1823_4943# 2.13e-21
C8 a3 a_3072_4399# 0.001761f
C9 a_995_4399# a_2263_4221# 0.036344f
C10 a_1037_4625# a_2520_3855# 2.05e-20
C11 b0 a_1775_6696# 0.743442f
C12 a_5821_5101# a_2283_5487# 0.001813f
C13 a_4399_4943# a_4031_5487# 0.033431f
C14 a_3517_5487# a_3471_6031# 0.005129f
C15 a_3471_2045# a_3537_1367# 4.19e-19
C16 a_1775_854# a_1907_591# 0.017809f
C17 a_5009_6183# b2 2.1e-21
C18 b5 a_1823_4943# 1.43605f
C19 a_3387_6031# a_501_5719# 1.05e-19
C20 a_553_1679# a_1527_2045# 0.034901f
C21 a_961_1831# a_1508_1135# 0.247892f
C22 a2 a_3655_2767# 9.56e-21
C23 a_947_4520# a_1420_5487# 2.66e-20
C24 a_1251_1501# a_1676_1501# 8.12e-20
C25 a_883_2589# a_1421_2919# 4.87e-20
C26 a_573_4105# a_1907_4221# 3.87e-21
C27 a_259_1831# a_443_591# 1.74e-19
C28 a_2235_1256# a_4011_3133# 1.83e-22
C29 a_947_4520# a_1420_5853# 1.94e-20
C30 a5 a_355_1653# 0.010823f
C31 b3 a_3931_3855# 2.46e-20
C32 a_481_6281# a_2263_4943# 1.33e-20
C33 a5 a_5345_1929# 1.1e-19
C34 b2 a_248_4631# 1.05e-19
C35 a5 a_947_4520# 0.003095f
C36 a1 a_1037_4625# 0.037389f
C37 b1 a_2341_2455# 2.96e-21
C38 a_1784_1679# a_1775_4118# 0.72753f
C39 a_317_2455# a_895_1135# 4.75e-21
C40 a_1987_3133# a_2244_2767# 0.02283f
C41 a_4931_2589# a_1697_743# 7.6e-19
C42 a_5135_6031# a_1692_4399# 0.001569f
C43 a_4268_2767# a_1823_4943# 2.98e-20
C44 a_763_1256# a_1676_1135# 1.9e-19
C45 a2 a_2157_5719# 0.040655f
C46 a5 a_5227_3855# 0.124415f
C47 a_5173_3631# a_3891_3432# 1.53e-19
C48 a_3168_3311# a_849_4105# 1.68e-19
C49 a_4533_2449# a_5095_1929# 7.3e-20
C50 a_3261_6183# a_4031_5487# 0.002948f
C51 a_1039_1942# a_1907_591# 2.76e-20
C52 DVDD a_2243_1929# 0.191782f
C53 a_4544_3855# a_5075_1148# 1.06e-20
C54 a_1067_5487# a_443_4943# 0.005458f
C55 a2 a_3663_1135# 4.21e-21
C56 a_4931_2223# a_1775_854# 0.003994f
C57 a_5863_5309# a_5653_5095# 0.012109f
C58 a_6219_5309# a_4399_4943# 0.017703f
C59 a_6644_5309# a_1823_4943# 2.16e-22
C60 a_1067_5853# a_443_4943# 0.005557f
C61 a_4457_743# a_5345_1929# 0.01527f
C62 a_2325_5713# b3 6.29e-19
C63 a_757_6281# a_849_3017# 4.72e-19
C64 b1 a_317_5095# 0.008795f
C65 DVDD a_1823_4943# 1.1917f
C66 a_1329_6183# a_2367_5487# 1.25e-19
C67 a_3387_6031# a2 0.003602f
C68 a_2815_3311# a_3168_3311# 2.18e-19
C69 a_763_1256# a_485_749# 0.009706f
C70 a_4535_854# a_4528_1135# 7.42e-20
C71 a_2325_5713# a_3076_5487# 1.17e-19
C72 a_5545_2925# a_5821_5101# 6.53e-21
C73 a_2341_2455# a_5779_4943# 3.63e-20
C74 a_1236_2223# a_355_1653# 2.99e-20
C75 a_883_2223# a_2045_2223# 2.17e-20
C76 a_4457_743# a_5227_3855# 0.001033f
C77 a_4943_1653# a_6412_4007# 0.003517f
C78 a_2341_2455# a_3471_1679# 7.25e-19
C79 b4 a_4351_5206# 0.226815f
C80 b0 a_573_4719# 1.21e-19
C81 b1 a_1079_4765# 9.68e-19
C82 a_443_591# a_5075_1148# 0.284862f
C83 a1 a_905_4399# 3.33e-20
C84 a_763_1256# a_1125_3017# 2.95e-19
C85 a_2377_2589# a_2467_2223# 0.006958f
C86 a_2551_2589# a_2045_2223# 0.017809f
C87 a_2235_1256# a_2688_957# 1.11e-19
C88 a_4636_3311# a_3799_4118# 4.96e-19
C89 a_1037_4625# a_2417_4625# 1.6e-19
C90 a_984_6183# a_883_4943# 2.23e-19
C91 a_995_4399# a_2327_4520# 7.82e-19
C92 a_2980_5487# a_3941_5853# 2.33e-19
C93 a_395_2344# a_2467_2223# 1.08e-20
C94 a_1455_6031# a_4115_5853# 5.17e-19
C95 a_2980_1135# a_5779_4943# 0.004559f
C96 a_2249_4631# a_2249_3543# 0.003018f
C97 a_481_6281# a_1895_6031# 0.005557f
C98 a_627_5487# a_1308_5309# 8.44e-20
C99 a_1823_6575# a_1907_5309# 0.107253f
C100 a_4528_6941# a_1775_6696# 7.35e-20
C101 a_2980_1135# a_3471_1679# 2.35e-19
C102 a_3297_6031# a_3537_6807# 7.03e-21
C103 a_984_6183# b3 2.07e-20
C104 b4 a_2340_3133# 6.24e-20
C105 a_1508_1135# a_443_591# 2.07e-20
C106 a_2157_5719# a_2815_4399# 3.79e-21
C107 a_2616_6575# DVDD 4.94e-19
C108 a_4471_4765# a_4896_4765# 8.12e-20
C109 a_3813_3543# a_3847_3855# 0.039224f
C110 a_1401_3855# a_849_4105# 4.73e-19
C111 a_3523_3030# a_3072_3311# 0.176054f
C112 a_4751_1831# a_5188_2223# 7.11e-20
C113 a_2493_1929# a_2341_2455# 2.39e-19
C114 a_5837_1831# a_6828_1679# 3.15e-19
C115 a_2263_3855# a_849_4105# 0.036485f
C116 a_5009_6183# a_5219_6397# 0.011205f
C117 a_3387_6031# a_5575_6397# 0.005326f
C118 a_5135_6031# a_5045_6397# 0.006823f
C119 a_4625_749# a_3537_1367# 8.21e-20
C120 a_1308_2223# a_961_1831# 1.88e-20
C121 a_2235_1256# a_1527_1679# 9.24e-21
C122 a3 a_619_3677# 0.001083f
C123 a_1784_1679# a_317_743# 0.006362f
C124 a5 a_2412_2767# 8.6e-20
C125 a_553_1679# a_2493_1929# 0.009188f
C126 a_757_6281# a_1860_4399# 2.39e-20
C127 a_2327_3432# a_1421_2919# 0.001318f
C128 a_3523_3030# a_4379_3311# 0.004531f
C129 a_4636_3311# a4 0.001004f
C130 a_2327_4520# a_2235_5608# 0.001348f
C131 a5 a_3931_3855# 0.004682f
C132 a_2520_6575# a_3241_6895# 7.82e-20
C133 a_2263_6941# a_2157_5719# 2.14e-20
C134 a_5923_2223# a_6403_2045# 0.001061f
C135 a_3609_4399# a_3072_4399# 0.173037f
C136 a_2249_4631# a_5653_5095# 0.025013f
C137 a_3983_4520# a_1823_4943# 4.61e-19
C138 a_2375_4399# a_4399_4943# 0.00954f
C139 a_527_957# a_443_591# 0.030161f
C140 a_995_4399# a_4115_4399# 9.53e-20
C141 a_627_5487# a_2616_6941# 0.001166f
C142 a_4824_5853# a_3905_5719# 5.43e-19
C143 a_4351_5206# a_4031_5487# 0.077579f
C144 a_5837_1831# a_6296_2767# 0.005581f
C145 a5 a_3168_3677# 2.53e-19
C146 a_2520_3855# a_1775_4118# 0.104293f
C147 a_849_3017# a_1987_2767# 0.005557f
C148 b3 a_4824_4765# 9.26e-23
C149 DVDD a_763_1256# 1.56982f
C150 a_3537_6807# a_627_5487# 0.859228f
C151 a_1039_1942# a_895_1501# 5.4e-19
C152 a4 a_2723_1501# 3.89e-20
C153 DVDD a_2459_4765# 0.001386f
C154 a_2325_5713# a_1420_5487# 1.26e-20
C155 a_1125_3017# a_1987_3133# 0.036048f
C156 DVDD a_3260_2223# 5.18e-19
C157 a_2980_5487# a_2520_6575# 1.02e-19
C158 a_6403_1679# a_6756_1679# 2.18e-19
C159 a_757_6281# a_1329_6183# 7.72e-19
C160 a_5873_1679# a_3663_1135# 1.45e-19
C161 a_1308_4943# a_1823_4943# 4.35e-20
C162 a_2980_5487# a_1823_6575# 8.18e-22
C163 a_1497_6189# a_627_5487# 4.66e-19
C164 a_1455_6031# a_3537_6807# 0.060514f
C165 a3 a_3297_6031# 3.08e-19
C166 a_1784_1679# a_2367_1501# 0.04028f
C167 a_3481_2767# a_3571_2767# 0.006958f
C168 a1 a_1775_4118# 0.001044f
C169 a_3655_2767# a_3164_2223# 0.049646f
C170 a_6219_4943# a_5545_2925# 1.2e-20
C171 a_2980_5487# b4 4.83e-20
C172 a_3261_6183# a_2375_4399# 3.1e-20
C173 b3 a_883_4943# 4.87e-19
C174 b0 a_2248_6031# 8.29e-20
C175 a_1455_6031# a_2248_6397# 3.72e-19
C176 a3 a_1907_3855# 0.008749f
C177 a0 a_4839_5309# 0.002972f
C178 b5 a_1733_3855# 2.92e-20
C179 a_5541_4719# a_4031_5487# 2.82e-19
C180 a_2907_2589# a_3332_2589# 8.12e-20
C181 a_3827_6397# a_4180_6397# 2.18e-19
C182 a_1497_6189# a_1455_6031# 0.401769f
C183 b5 a_6020_3855# 8.27e-21
C184 b2 a_4728_4399# 5.13e-20
C185 a_984_6183# a_1420_5487# 0.004869f
C186 a_961_1831# a_685_1367# 0.160315f
C187 a_317_743# a_1733_957# 3.02e-20
C188 a_3813_3543# a_4544_3855# 0.163942f
C189 a_395_854# a_1308_957# 6.08e-19
C190 a_485_749# a_1236_957# 2.3e-19
C191 a_3523_3030# a_4287_4221# 2.43e-21
C192 b2 a_4709_1929# 7.31e-22
C193 a_2327_3432# a_2781_2767# 0.009537f
C194 P11 a_2493_1679# 0.002065f
C195 a_2375_3311# a_3931_3855# 6.74e-21
C196 a_3523_3030# a_3891_3432# 0.169061f
C197 a_757_6281# a_1037_4625# 0.461935f
C198 a_984_6183# a_1420_5853# 0.006224f
C199 a_2377_2589# a_2341_2455# 6.46e-20
C200 DVDD a_4115_5853# 0.034638f
C201 b5 a_445_3311# 6.29e-21
C202 a_3537_1367# a_3573_1135# 2.4e-20
C203 a_984_6183# a5 0.04909f
C204 a_395_2344# a_2341_2455# 4.46e-21
C205 a_481_6281# a1 0.142961f
C206 a3 a_2688_6941# 5.93e-20
C207 b2 a_3072_3311# 0.018272f
C208 a1 a_3517_5807# 8.03e-20
C209 a_2723_5487# a_3148_5487# 1.31e-19
C210 a_2157_5719# a_3905_5719# 0.003886f
C211 a_4351_5206# a_4471_5487# 0.064048f
C212 P9 a_395_854# 0.128346f
C213 P10 a_317_743# 0.027678f
C214 a_2327_3432# a_3240_3677# 2.57e-20
C215 P11 a_1823_3855# 0.016831f
C216 a_2375_3311# a_3168_3677# 3.73e-20
C217 a_219_1929# a_527_2589# 1.82e-20
C218 a_259_1831# a_883_2589# 1.15e-20
C219 a_4728_4399# a_4535_854# 2.47e-21
C220 a_4709_1929# a_4535_854# 0.042755f
C221 a_5587_2767# a_5943_2767# 0.008475f
C222 a2 a_3517_5487# 0.00418f
C223 a_3164_2223# a_3663_1135# 2.3e-19
C224 a3 a_627_5487# 0.158503f
C225 a_5503_2767# a_6756_1679# 5.46e-20
C226 b2 a_2263_4943# 3.26e-19
C227 a_2243_1929# a_2249_3543# 1.54e-20
C228 a_395_2344# a_553_1679# 0.001767f
C229 a_2375_4399# a_3168_4765# 5.78e-20
C230 DVDD a_1987_3133# 0.147778f
C231 b4 a_1457_3133# 2.61e-20
C232 a_3261_6183# a_4252_6031# 6.2e-20
C233 a_4667_591# a_395_854# 3.67e-20
C234 a_2249_4631# a_3240_4765# 5.64e-19
C235 a_763_1256# a_1880_1679# 3.73e-20
C236 DVDD a_1308_5309# 6.81e-19
C237 DVDD a_6000_6397# 4.72e-19
C238 b2 a_4379_3311# 0.003811f
C239 a_317_2455# a_573_4105# 9.3e-20
C240 a_355_1653# a_297_4105# 0.017192f
C241 a_4483_4943# a_3799_4118# 2.34e-20
C242 a_501_5719# a4 1.13e-21
C243 a_5689_4943# a_2375_4399# 2.09e-19
C244 a_1697_743# a_3076_1501# 2.75e-19
C245 a_1775_4118# a_2417_4625# 3.5e-20
C246 a_248_4631# a_573_4105# 0.018656f
C247 a_4636_3311# a_5779_4943# 1.91e-19
C248 a0 a_1508_1135# 2.11e-20
C249 a_1455_6031# a3 0.022728f
C250 a_5009_6183# a_2283_5487# 0.08346f
C251 a_5135_6031# a_2235_5608# 0.005295f
C252 a_3387_6031# a_3905_5719# 0.001326f
C253 a_2980_5487# a_4031_5487# 0.005148f
C254 a_3523_3030# a_3827_1679# 3.25e-20
C255 a_4943_1653# a_3537_1367# 2.35e-19
C256 a_2235_1256# a_4751_1831# 2.87e-20
C257 DVDD a_6296_3133# 4.48e-19
C258 a_5095_1929# a_5289_1433# 0.001691f
C259 DVDD a_3240_4399# 4.72e-19
C260 a_3164_2223# a_4103_1501# 6.83e-22
C261 a_4625_749# a_5075_1148# 0.172501f
C262 a_3571_2767# a_3747_1501# 0.024139f
C263 a_395_2344# a_317_5095# 2.01e-20
C264 a_2249_3543# a_1823_4943# 0.004441f
C265 a_3847_3855# a_1692_4399# 0.004545f
C266 a_2520_3855# a_317_743# 0.239346f
C267 a_5943_2767# a_5503_2767# 0.040592f
C268 a_355_1653# a_849_3017# 2.78e-21
C269 a_317_2455# a_1039_1942# 0.008394f
C270 a_2551_2223# a_1823_3855# 0.003489f
C271 a2 a_3799_4118# 0.018161f
C272 a_4364_2767# a_2341_2455# 2.28e-19
C273 a_947_4520# a_849_3017# 1.01e-19
C274 a_757_6281# a_905_4399# 5.12e-20
C275 b5 a_5587_2767# 2.97e-19
C276 DVDD a_445_3311# 5.31e-19
C277 a_4847_1653# a_1823_4943# 6.84e-19
C278 b4 a_4364_3133# 1.19e-19
C279 a_1733_6941# a_1775_6696# 1.11e-19
C280 a_4528_6575# b0 1.16e-19
C281 DVDD a_1236_957# 3.18e-19
C282 a_3523_3030# a_2520_3855# 2.83e-21
C283 a0 a_1492_5487# 5.28e-20
C284 a2 a_1823_3855# 2.8e-21
C285 a_3261_6183# a_3827_6397# 0.019624f
C286 a_1907_6575# b1 6.07e-19
C287 P5 a_1865_4013# 1.45e-20
C288 a_2375_4399# a_4351_5206# 8.13e-19
C289 DVDD a_3537_6807# 1.19975f
C290 a_5284_2589# a_3663_1135# 5.14e-21
C291 a0 a_1492_5853# 3.15e-19
C292 a1 a_1236_4943# 1.02e-19
C293 a_1823_4943# a_5653_5095# 0.046158f
C294 a_685_1367# a_443_591# 7.24e-20
C295 a3 a_1125_3017# 0.129725f
C296 a_3072_4399# a_4399_4943# 0.800325f
C297 DVDD a_6403_1679# 0.007874f
C298 a_995_4399# a_1631_2767# 5.03e-21
C299 b5 a_5503_2767# 0.034188f
C300 a_501_5719# a_1539_6031# 0.036672f
C301 a_6828_2045# a_1823_4943# 9.78e-20
C302 a_2248_6397# DVDD 2.76e-19
C303 a_501_5719# b1 0.064985f
C304 a_5009_6183# a_5689_5309# 4.8e-20
C305 a_3387_6031# a_5863_5309# 1.74e-20
C306 a1 P1 0.003206f
C307 a5 b3 0.457761f
C308 DVDD P8 0.185737f
C309 a_6403_2045# a_6756_2045# 2.18e-19
C310 a_5376_591# P7 0.005587f
C311 b5 a_6412_5719# 7.7e-20
C312 b0 P0 0.018124f
C313 a3 b5 0.185037f
C314 a2 a4 0.0312f
C315 a_1497_6189# DVDD 0.514317f
C316 a1 a_3523_3030# 6.67e-20
C317 a_1171_2045# a_395_854# 4.26e-21
C318 a_2249_4631# a_2263_5309# 8.78e-20
C319 a_4457_743# a_6173_2223# 0.03923f
C320 a_4709_1929# a_5376_957# 4.52e-20
C321 a2 a_5219_6031# 0.001749f
C322 a_5023_591# a_5448_591# 8.12e-20
C323 DVDD a_1604_1135# 7.98e-19
C324 b2 a_3891_3432# 0.254841f
C325 a_259_1831# a_883_591# 1.02e-19
C326 a_219_1929# a_527_591# 6.53e-21
C327 b2 a_975_3311# 5.83e-19
C328 a5 a_1328_3311# 8.3e-20
C329 b4 a_619_3311# 9.45e-19
C330 a_4073_4625# a_6092_4221# 1.22e-20
C331 a_2249_4631# a_6277_4719# 0.009673f
C332 a_2375_4399# a_5541_4719# 1.16e-19
C333 a_2341_2455# a_3076_1135# 1.71e-20
C334 b0 a_4471_4765# 2.55e-20
C335 DVDD a_5587_2767# 0.001417f
C336 a_1039_1942# a_1457_2767# 0.006958f
C337 a_3571_2767# a_4364_3133# 4.35e-21
C338 a_3164_2223# a_4436_3133# 1.05e-19
C339 a_5503_2767# a_4268_2767# 0.006908f
C340 a_1125_3017# a_4011_3133# 2.55e-20
C341 a_947_4520# a_1860_4399# 2.17e-19
C342 a_3813_3543# a_4471_4765# 4.66e-21
C343 a_6173_2543# a_5503_2767# 0.003009f
C344 a_3261_6183# a_3072_4399# 2.91e-20
C345 a_219_1929# a_395_2344# 0.005131f
C346 a_4535_854# a_3891_3432# 0.009191f
C347 a_1775_4118# a_2263_591# 1.07e-19
C348 a_527_2223# a_395_854# 4.98e-21
C349 a_763_1256# a_297_3017# 8.83e-21
C350 a_883_2223# a_317_743# 2.98e-19
C351 a_4544_3855# a_1692_4399# 0.004836f
C352 a_3076_1135# a_2980_1135# 0.005002f
C353 a_4533_2449# a_5227_3855# 4.17e-19
C354 a_5837_1831# a_1865_4013# 1.2e-20
C355 a_5311_4221# a_3847_3855# 1.08e-20
C356 a_5137_4221# a_5227_3855# 0.006823f
C357 a1 a_883_5309# 0.001364f
C358 a5 a_527_5309# 4.46e-21
C359 a_5223_1501# a_5075_1148# 0.005668f
C360 DVDD a_5503_2767# 0.774861f
C361 a_1775_6696# a_2235_5608# 0.00122f
C362 a_757_6281# a_1775_4118# 1.4e-19
C363 a_6644_5309# a_6412_5719# 0.007768f
C364 a_2249_4631# a_2157_5719# 2.1e-19
C365 b1 a2 0.292062f
C366 a_259_1831# a_1604_1501# 3.73e-20
C367 a0 b0 0.637858f
C368 DVDD a3 1.34113f
C369 DVDD a_6412_5719# 0.624686f
C370 a_4535_854# a_4860_1367# 0.026922f
C371 a_947_4520# a_1329_6183# 3.59e-20
C372 a4 a_6020_4221# 1.59e-19
C373 a_2412_2767# a_849_3017# 2.57e-20
C374 a_4379_3677# a_3072_3311# 0.001154f
C375 a_2907_2223# a_1697_743# 0.001792f
C376 a_4804_3677# a_1865_4013# 4.48e-20
C377 a_5943_3133# a4 0.004872f
C378 a4 a_2815_4399# 1.71e-20
C379 a_4023_3677# a_3847_3855# 0.004772f
C380 a0 a_3813_3543# 8.04e-21
C381 a_3523_3030# a_2417_4625# 7.83e-21
C382 a_1697_743# a_395_854# 0.089857f
C383 b4 a_4073_4625# 0.215266f
C384 a_2375_3311# b3 2.83e-20
C385 a_4011_3133# a_4268_2767# 0.02283f
C386 a_4709_1929# a_5345_1679# 0.003387f
C387 a_4943_1653# a_5075_1148# 1.27e-20
C388 a_2157_5719# a_2723_5853# 0.054124f
C389 a_3387_6031# a_2249_4631# 2.51e-20
C390 a_3168_4765# a_3072_4399# 0.005587f
C391 a_2980_5487# a_2375_4399# 7.4e-20
C392 a_1455_6031# a_3609_4399# 4.15e-21
C393 a_1067_5487# a_1492_5487# 1.31e-19
C394 a_1236_591# a_443_591# 3.87e-19
C395 a_409_3543# a_1435_4399# 1.26e-20
C396 a_1823_6575# a_1865_4013# 0.001601f
C397 b2 a_2520_3855# 0.087745f
C398 a_5023_591# a_4535_854# 0.006158f
C399 P11 a_2493_1929# 0.071248f
C400 DVDD a_997_2045# 4.94e-19
C401 a_2616_957# a_1865_749# 2.35e-19
C402 a_757_6281# a_481_6281# 0.061994f
C403 a_5264_4943# a_4399_4943# 0.001131f
C404 a_4709_1929# a_1775_854# 0.036942f
C405 a_355_1653# a_2045_2223# 1.35e-20
C406 a_4457_743# P7 0.109702f
C407 b4 a_1865_4013# 0.211522f
C408 P3 a_2520_6575# 6.08e-20
C409 a_995_4399# a_573_4719# 3.36e-20
C410 a_4073_4625# a_5413_2767# 2.03e-21
C411 DVDD a_4011_3133# 0.165391f
C412 a_1067_5853# a_1492_5853# 8.12e-20
C413 a_501_5719# a_711_5487# 0.011205f
C414 a_5376_591# a_4457_743# 2.6e-19
C415 a_947_4520# a_1037_4625# 0.679293f
C416 a_3517_5487# a_3905_5719# 0.001667f
C417 a_501_5719# a_711_5853# 0.04028f
C418 a_2980_5487# a_3076_5853# 0.005587f
C419 a2 a_5779_4943# 1.21e-21
C420 a4 a_5873_1679# 4.53e-20
C421 P3 b4 0.00116f
C422 a1 b2 0.115473f
C423 a_2467_2223# a_3847_3855# 6.88e-19
C424 DVDD a_6572_5309# 6.42e-19
C425 DVDD a_353_2223# 5.88e-19
C426 a_995_4399# a_3847_3855# 0.266489f
C427 a_4252_2045# a_3847_3855# 4.46e-20
C428 a_3523_3030# a_4436_2767# 2.57e-20
C429 a_3813_3543# a_4805_2767# 0.009374f
C430 a_3523_3030# a_4471_4399# 1.79e-20
C431 a_2327_3432# a_1508_1135# 0.004701f
C432 b1 a_2815_4399# 0.003594f
C433 b3 a_3471_6397# 1.26e-19
C434 a_3799_4118# a_3164_2223# 4.65e-19
C435 a_4544_3855# a_5311_4221# 2.29e-21
C436 a_3387_6031# a_4180_6031# 0.001183f
C437 a_2980_5487# a_4252_6031# 2.57e-20
C438 a_4751_1831# a_2244_2767# 3.53e-19
C439 DVDD a_4824_5487# 2.85e-19
C440 b5 a_5923_2223# 1.03e-20
C441 a_4728_4399# a_2283_5487# 7.5e-19
C442 a_5587_3133# a_3891_3432# 0.002126f
C443 a_2263_3855# a_1907_3855# 0.008475f
C444 a_4073_4625# a_4031_5487# 0.175678f
C445 a_4712_3855# a_4544_3855# 0.008883f
C446 a_3072_4399# a_4351_5206# 0.777809f
C447 a_3799_4118# a_3905_5719# 8.06e-20
C448 b5 a_3609_4399# 2.52e-19
C449 a1 a_4535_854# 6.62e-19
C450 a_961_1831# a_2467_2223# 4.74e-20
C451 a_2263_591# a_317_743# 0.004655f
C452 a_1733_591# a_485_749# 0.006958f
C453 a_1775_4118# a_1251_1501# 1.11e-20
C454 a1 a_1788_4765# 1.34e-19
C455 a_1987_2767# a_1775_4118# 2.08e-19
C456 a_1508_1135# a_1604_1501# 0.005657f
C457 a2 a_2263_4221# 4.51e-20
C458 P0 a_1692_4399# 3.69e-20
C459 a_5837_1831# a_1697_743# 6.13e-19
C460 a_3164_2223# a_1865_749# 1.46e-20
C461 a_4103_1135# a_3663_1135# 0.006871f
C462 a5 a_4457_743# 0.001866f
C463 a_3164_2223# a_1823_3855# 4.92e-20
C464 a_3571_2767# a_1865_4013# 0.001824f
C465 a_2320_6031# a_1329_6183# 4.08e-19
C466 a_2815_3677# a_1865_4013# 0.001031f
C467 a_2459_3677# a_1823_3855# 0.009132f
C468 a_1784_1679# a_1775_854# 0.116397f
C469 a_2285_3677# a_3072_3311# 2.68e-20
C470 a_4379_3677# a_3891_3432# 0.010496f
C471 b0 a_1067_5487# 5.28e-20
C472 a2 a_711_5487# 1.24e-19
C473 a_3072_3311# a_2283_5487# 1.08e-20
C474 a_1823_4943# a_2263_5309# 0.003858f
C475 a_4252_6397# a_3537_6807# 0.007921f
C476 P7 a_5023_957# 0.02283f
C477 a3 a_1308_4943# 9.72e-20
C478 a_2616_4943# a_2235_5608# 6.28e-20
C479 a_1784_1679# a_997_1679# 2.99e-20
C480 a_5923_2223# a_4268_2767# 8.21e-19
C481 b0 a_1067_5853# 5.15e-21
C482 b4 a_527_2223# 1.26e-19
C483 a5 a_1236_2223# 8.3e-20
C484 a_2815_4765# a_3168_4765# 2.18e-19
C485 DVDD a_2688_957# 4.72e-19
C486 a_4023_3311# a_3164_2223# 1.1e-19
C487 a_6173_2543# a_5923_2223# 0.007234f
C488 a_5356_2223# a_4535_854# 1.3e-19
C489 a_5943_3133# a_5779_4943# 0.007241f
C490 a4 a_3164_2223# 0.082805f
C491 a_501_5719# a_2327_4520# 2.43e-22
C492 a_1539_6397# a0 0.006674f
C493 b2 a_2417_4625# 0.125169f
C494 b2 a_2551_2589# 5.9e-19
C495 a_1784_1679# a_573_4105# 3.27e-20
C496 a_5667_3855# a_5821_5101# 2.09e-20
C497 a_6020_3855# a_5653_5095# 0.006376f
C498 a_757_6281# P1 0.015606f
C499 a_4379_3311# a_2283_5487# 1e-21
C500 a_1455_6031# a_4180_6397# 2.42e-21
C501 a5 a_2375_3311# 0.035935f
C502 a_2980_5487# a_3827_6397# 0.005326f
C503 a_5045_6031# a_4031_5487# 8.39e-19
C504 b2 a_2367_5487# 0.009889f
C505 a_3148_1501# a_3663_1135# 4.35e-20
C506 DVDD a_5923_2223# 0.214911f
C507 a_1784_1679# a_1039_1942# 0.07528f
C508 a_3655_3133# a_1865_4013# 6.9e-20
C509 a_1697_743# a_6047_1679# 3.36e-19
C510 DVDD a_3609_4399# 0.591072f
C511 a_883_2589# a_685_1367# 0.023012f
C512 b2 a_5095_1929# 3.4e-20
C513 DVDD a_1527_1679# 0.002516f
C514 b4 a_1697_743# 3.13e-20
C515 a_1775_854# a_3891_3432# 2.6e-19
C516 a_995_4399# a_4544_3855# 0.060017f
C517 a_3261_6183# a_3297_6031# 4.78e-19
C518 a_4073_4625# a_4471_5487# 2.05e-20
C519 a_2157_5719# a_1823_4943# 1.75e-19
C520 a_3799_4118# a_4115_5487# 1.4e-19
C521 a_2520_6575# a_5821_5101# 5.85e-19
C522 a_2325_5713# a_1329_6183# 0.002599f
C523 a_4103_1135# a_4456_1135# 2.18e-19
C524 a_4728_4399# a_5545_2925# 2.43e-19
C525 a0 a_1692_4399# 0.008339f
C526 a_4575_2589# a_3847_3855# 0.019052f
C527 b3 a_297_4105# 5.38e-20
C528 a_627_5487# a_4399_4943# 2.14e-21
C529 a_1775_6696# a_2193_5853# 5.49e-21
C530 a0 a_3977_4943# 2.06e-19
C531 a_4309_4943# a_2417_4625# 4.56e-20
C532 a_3663_1135# a_1823_4943# 0.004414f
C533 a_4943_1653# a_3813_3543# 1.83e-20
C534 a_757_6281# a_883_5309# 0.006304f
C535 a_1037_4625# a_3168_3677# 2.34e-20
C536 a_259_1831# a_469_1679# 3.52e-19
C537 a_1775_854# a_1733_957# 2.38e-20
C538 a_5095_1929# a_4535_854# 0.013625f
C539 a_4751_1831# a_5943_2767# 1.34e-19
C540 a_1775_854# a_4860_1367# 7.85e-20
C541 a_4709_1929# a_5923_1135# 9.96e-19
C542 b1 a_3164_2223# 5.97e-20
C543 a_2467_2223# a_443_591# 3.82e-20
C544 a_5345_1929# a_5289_1433# 1.35e-19
C545 a_2980_5487# a_3072_4399# 1.76e-20
C546 a_2459_3311# a_1865_4013# 2.73e-20
C547 a_2341_2455# a_3847_3855# 0.06276f
C548 a4 a_5863_5309# 1.57e-19
C549 b3 a_849_3017# 0.038215f
C550 a_5284_2589# a4 2.28e-19
C551 a_5264_4943# a_4351_5206# 6.11e-20
C552 a1 a_5667_4221# 0.001117f
C553 a2 a_2327_4520# 7.23e-19
C554 a1 a_2459_4399# 0.003092f
C555 b1 a_3905_5719# 0.199781f
C556 DVDD a_3168_3311# 4.96e-19
C557 P5 a_2688_5309# 0.007578f
C558 a3 a_2249_3543# 0.018751f
C559 a3 a_297_3017# 0.037668f
C560 a_4287_4221# a_2283_5487# 3.84e-20
C561 b5 a_1401_3855# 2.93e-20
C562 a_984_6183# a_1329_6183# 0.019615f
C563 a_2616_6575# a_2157_5719# 5.11e-21
C564 a_1775_854# a_3827_1679# 0.04343f
C565 a_2467_2223# a_4180_1679# 7.33e-20
C566 a_573_4719# a_317_5095# 0.009999f
C567 a_4535_854# a_4667_957# 0.036672f
C568 a_6412_4007# a_5075_1148# 8.68e-20
C569 a_317_743# a_1251_1501# 0.001331f
C570 a_3847_3855# a_2980_1135# 1.08e-21
C571 a_5227_3855# a_5289_1433# 1.54e-22
C572 a_2327_3432# a_3813_3543# 1.19e-19
C573 a_4732_3311# a_2341_2455# 1.76e-19
C574 a_3891_3432# a_2283_5487# 1.04e-20
C575 b5 a_2263_3855# 0.00213f
C576 a2 a_2193_5487# 3.38e-20
C577 a_947_4520# a_1775_4118# 0.006101f
C578 a_3537_1367# a_4709_1679# 6.81e-20
C579 a_3261_6183# a_627_5487# 0.140168f
C580 a_6644_4943# a_1823_4943# 5.58e-20
C581 a_1697_743# a_3571_2767# 0.11832f
C582 a_961_1831# a_2341_2455# 7.54e-20
C583 a_4457_743# a_5023_957# 0.018344f
C584 a_4824_4399# a_1692_4399# 1.41e-19
C585 a_3517_5487# a_2723_5853# 3.36e-19
C586 a_763_1256# a_409_3543# 2.27e-20
C587 a_2375_4399# a_4073_4625# 0.0169f
C588 a_395_2344# a_469_1929# 0.001445f
C589 a_961_1831# a_553_1679# 0.094781f
C590 a_3609_4399# a_3983_4520# 0.86055f
C591 a_2249_4631# a_3799_4118# 0.033349f
C592 a_1455_6031# a_3261_6183# 0.524297f
C593 b3 a_849_2767# 3.69e-19
C594 a_1907_957# a_2263_957# 0.009846f
C595 a_4471_5853# a_4351_5206# 0.024935f
C596 a_3471_2045# a_2467_2223# 0.033026f
C597 a_1775_854# a_2520_3855# 0.03339f
C598 a_1527_1679# a_1880_1679# 2.18e-19
C599 a_5503_2767# a_5653_5095# 8.26e-20
C600 P5 a_2616_5309# 0.004869f
C601 a_3164_2223# a_3471_1679# 1.02e-20
C602 a_995_4399# a_2616_4221# 3.67e-19
C603 a_1421_2919# a_1508_1135# 0.204563f
C604 a_481_6281# a_947_4520# 2.91e-19
C605 a_5653_5095# a_6412_5719# 0.123644f
C606 a_5188_2223# a_1865_4013# 8.12e-20
C607 a_757_6281# b2 0.027466f
C608 a_5821_5101# a_4031_5487# 0.004995f
C609 a_984_6183# a_1037_4625# 4.56e-19
C610 a_3827_2045# a_4180_2045# 2.18e-19
C611 b5 a_4399_4943# 6.8e-19
C612 a_685_1367# a_883_591# 1.48e-20
C613 a_553_1679# a_1880_2045# 4.57e-19
C614 a_2249_4631# a_1823_3855# 0.003959f
C615 a_2375_4399# a_1865_4013# 0.001424f
C616 b3 a_3983_5608# 0.011225f
C617 a_2157_5719# a_2459_4765# 6.32e-21
C618 DVDD a_4180_6397# 2.76e-19
C619 a_4751_1831# a_4268_2767# 6.63e-20
C620 a_2459_4399# a_2417_4625# 0.089068f
C621 a_2815_4399# a_2327_4520# 0.025309f
C622 a_1865_4013# a_849_4105# 0.008879f
C623 a_1952_2045# a_1775_4118# 1.08e-19
C624 a_395_2344# a_1236_2589# 7.33e-20
C625 DVDD a_2263_3855# 8.16e-19
C626 a4 a_2249_4631# 0.149368f
C627 P0 a_995_4399# 1.16e-19
C628 a_1987_3133# a_2412_3133# 1.31e-19
C629 a_2244_2767# a_2340_3133# 0.004869f
C630 a_2341_2455# a_4544_3855# 0.10806f
C631 a_1039_1942# a_2520_3855# 2.08e-20
C632 a_757_6281# a_1788_4765# 2.54e-19
C633 a1 a_573_4105# 5.95e-19
C634 a_5545_2925# a_3891_3432# 0.032515f
C635 b3 a_3849_3677# 2.4e-20
C636 a3 a_1733_4221# 3.56e-20
C637 a5 a_297_4105# 0.121115f
C638 DVDD a_4751_1831# 0.468386f
C639 a_4535_854# a_5002_1501# 7.88e-19
C640 a_5587_3133# a_5095_1929# 1.59e-20
C641 a_2616_4221# a_2235_5608# 1.48e-20
C642 a_4103_6575# a_3905_5719# 9.55e-20
C643 P6 a_6412_4007# 0.091044f
C644 a5 a_3517_4943# 2.8e-22
C645 a_5009_6183# a_4839_4943# 0.023038f
C646 a_4103_6941# b0 0.003799f
C647 a_395_854# a_2723_1135# 6.03e-19
C648 b3 a_1329_6183# 9.75e-21
C649 a_1492_5487# a_443_4943# 3.18e-19
C650 a_995_4399# a_4471_4765# 1e-20
C651 a_3481_2767# a_2244_2767# 3.72e-20
C652 a_685_1367# a_1604_1501# 8.15e-19
C653 a_1697_743# a_2459_3311# 3.52e-21
C654 a_1987_3133# a_409_3543# 1.14e-20
C655 a_5863_5309# a_5779_4943# 0.030161f
C656 a_6219_5309# a_5821_5101# 0.083008f
C657 a_1823_6575# a_2688_5309# 1.23e-20
C658 a_6644_5309# a_4399_4943# 2.17e-19
C659 a_5284_2589# a_5779_4943# 9.65e-20
C660 a_1492_5853# a_443_4943# 2.57e-20
C661 a5 a_849_3017# 0.045599f
C662 a_4457_743# a_6047_2045# 4.75e-19
C663 DVDD a_4399_4943# 0.942393f
C664 a_317_2455# a_395_854# 0.001121f
C665 a_355_1653# a_317_743# 2.75e-19
C666 a1 a_2283_5487# 0.248113f
C667 a_5135_6031# a2 6.1e-19
C668 a_2412_2767# a_1775_4118# 1.93e-19
C669 DVDD a_6756_2045# 2.76e-19
C670 a_4533_2449# a_5081_2767# 0.009542f
C671 a_627_5487# a_4351_5206# 6.86e-22
C672 a_4535_854# a_5002_1174# 5.44e-19
C673 a_553_1679# a_443_591# 5.69e-21
C674 a_1037_4625# a_883_4943# 8.11e-19
C675 a_2341_2455# a_4180_1679# 5.24e-20
C676 a_763_1256# a_1631_3133# 2.94e-21
C677 a_443_591# a_2980_1135# 0.045374f
C678 a4 a_1435_4399# 9.33e-19
C679 a_2907_2589# a_2467_2223# 0.031328f
C680 a_3260_2589# a_2045_2223# 7.33e-20
C681 a_4625_749# a_4877_1679# 3.84e-20
C682 a0 a_995_4399# 0.03038f
C683 b3 a_2045_2223# 0.090715f
C684 a_5095_1929# a_5345_1679# 0.007234f
C685 b1 a_2249_4631# 0.060731f
C686 a3 a_3240_4765# 1.51e-19
C687 a_4115_4765# a_2283_5487# 3.9e-19
C688 b3 a_1037_4625# 0.013097f
C689 P1 a_947_4520# 0.00207f
C690 a_445_3311# a_409_3543# 2.48e-20
C691 a_883_591# a_1236_591# 2.18e-19
C692 b4 a_895_1501# 8.19e-20
C693 a_219_1929# a_961_1831# 0.01285f
C694 a_481_6281# a_2320_6031# 2.57e-20
C695 a_1823_6575# a_2616_5309# 1.71e-20
C696 a_1907_6575# a_1775_6696# 0.020012f
C697 a5 a_849_2767# 2.58e-19
C698 a_2375_4399# a_2688_3855# 4.19e-22
C699 a_2327_3432# a_1692_4399# 8.89e-20
C700 a_3261_6183# DVDD 1.53246f
C701 a_4636_3311# a_3847_3855# 1.79e-19
C702 a_5095_1929# a_1775_854# 0.223534f
C703 a_1697_743# a_5188_2223# 0.002403f
C704 a_3471_2045# a_2341_2455# 0.00265f
C705 a_501_5719# a_1775_6696# 0.001639f
C706 a_1455_6031# a_1907_5309# 1.8e-20
C707 a_883_2223# a_1039_1942# 0.001022f
C708 a_3387_6031# a_6000_6397# 2.43e-19
C709 a_5135_6031# a_5575_6397# 0.005323f
C710 a_2243_1929# a_2493_1679# 0.007234f
C711 a_1697_743# a_1171_1679# 2.57e-19
C712 a_2244_2767# a_3747_1501# 4.79e-20
C713 a_2459_3677# a_2327_4520# 2.97e-20
C714 a5 a_4533_2449# 0.001061f
C715 a_2375_3311# a_849_3017# 0.001132f
C716 b0 a_443_4943# 0.051211f
C717 a_1952_2045# a_317_743# 2.8e-20
C718 a_4636_3311# a_4732_3311# 0.004869f
C719 a0 a_2235_5608# 0.0641f
C720 a_553_1679# a_3471_2045# 1.01e-19
C721 a_2417_4625# a_2283_5487# 3.04e-20
C722 a_3471_2045# a_2980_1135# 1.36e-19
C723 a_1697_743# a_849_4105# 0.001582f
C724 a5 a_4640_3855# 1.49e-19
C725 a_947_4520# a_883_5309# 2.75e-20
C726 a_4073_4625# a_3072_4399# 0.023353f
C727 a_3983_4520# a_4399_4943# 0.003654f
C728 a_3799_4118# a_1823_4943# 0.07483f
C729 a_2249_4631# a_5779_4943# 0.028604f
C730 a_3609_4399# a_5653_5095# 3.94e-20
C731 a1 a_3941_5487# 4.48e-20
C732 a_2243_1929# a_1865_749# 1.54e-20
C733 a_2375_4399# a_5821_5101# 0.023026f
C734 a_2235_1256# a_1865_4013# 5.98e-21
C735 a_2243_1929# a_1823_3855# 0.205411f
C736 a1 a_5545_2925# 1.05e-20
C737 a_3537_6807# a_2157_5719# 0.002392f
C738 a_627_5487# a_3241_6895# 2.36e-19
C739 b1 a_1435_4399# 0.009182f
C740 a_2723_5487# a_2235_5608# 0.014035f
C741 a_2367_5487# a_2283_5487# 0.030161f
C742 a_4103_6941# a_4528_6941# 8.12e-20
C743 b5 a_4351_5206# 3.5e-19
C744 a_2325_5713# a_481_6281# 0.001144f
C745 a5 a_3849_3677# 1.58e-19
C746 b3 a_905_4399# 4.66e-20
C747 a_2688_4221# a_1775_4118# 1.9e-19
C748 a4 a_2243_1929# 0.002159f
C749 a_1631_3133# a_1987_3133# 0.009846f
C750 a_1125_3017# a_2340_3133# 4.34e-19
C751 DVDD a_4401_2223# 4.94e-19
C752 a_1865_4013# a_3072_4399# 0.001417f
C753 a5 a_1329_6183# 4.14e-19
C754 a_1823_3855# a_1823_4943# 0.021106f
C755 a_1497_6189# a_2157_5719# 0.003494f
C756 a_5009_6183# a_2520_6575# 0.034966f
C757 a_1907_4943# a_1823_4943# 0.062128f
C758 a_4457_743# a_4533_2449# 0.029253f
C759 a3 a_2263_5309# 3.14e-19
C760 P8 a_3663_1135# 4.94e-19
C761 a_2980_5487# a_627_5487# 0.008499f
C762 a_3387_6031# a_3537_6807# 0.198792f
C763 a_1784_1679# a_3076_1501# 5.43e-19
C764 a_2249_4631# a_2263_4221# 5.24e-19
C765 a2 a_1775_6696# 0.341829f
C766 a_3571_2767# a_3941_4399# 1.88e-21
C767 a_4364_2767# a_3164_2223# 5.43e-19
C768 a_4011_2767# a_3571_2767# 0.042762f
C769 a_3261_6183# a_3983_4520# 6.9e-20
C770 a_1455_6031# a_481_6031# 2.52e-21
C771 a_4493_591# a_3663_1135# 7.32e-20
C772 a_5009_6183# b4 7.54e-19
C773 P0 a_317_5095# 0.010625f
C774 a_1775_854# a_2263_591# 0.006039f
C775 a4 a_1823_4943# 0.035679f
C776 a0 a_5264_5309# 3.97e-20
C777 a_4471_4399# a_2283_5487# 3.36e-20
C778 a_1455_6031# a_2980_5487# 1.05775f
C779 a_1497_6189# a_3387_6031# 3.73e-20
C780 a3 a_409_3543# 0.034425f
C781 a_984_6183# a_481_6281# 0.058143f
C782 a_685_1367# a_1421_2919# 0.006319f
C783 a_219_1929# a_443_591# 7.41e-21
C784 b5 a_6737_3855# 3.11e-19
C785 a1 a_1435_4765# 0.002298f
C786 a_5587_2767# a_3663_1135# 5.19e-19
C787 b4 a_317_2455# 0.003313f
C788 a_4636_3311# a_4544_3855# 0.042157f
C789 a5 a_2045_2223# 0.033527f
C790 b4 a_248_4631# 1.34e-21
C791 b2 a_947_4520# 0.087739f
C792 a5 a_1037_4625# 0.041048f
C793 a_3523_3030# a_3931_3855# 7.99e-20
C794 a_984_6183# a_1861_5807# 7.19e-20
C795 a_2907_2589# a_2341_2455# 0.047713f
C796 DVDD a_4351_5206# 1.32041f
C797 a_259_1831# a_1508_1135# 0.049605f
C798 a_2263_3855# a_2249_3543# 5.81e-19
C799 a_2263_3855# a_2616_3855# 2.18e-19
C800 b2 a_5227_3855# 0.002116f
C801 a3 a_2157_5719# 0.283509f
C802 a_757_6281# a_573_4105# 3.24e-19
C803 a_3481_2767# a_4268_2767# 2.89e-20
C804 a_961_1831# a_883_957# 4.39e-21
C805 b0 a_1401_6895# 2.94e-19
C806 a_5943_2767# a_6296_2767# 2.18e-19
C807 a_5345_1929# a_4535_854# 0.002229f
C808 a_5503_2767# a_3663_1135# 0.007055f
C809 DVDD a_2340_3133# 2.76e-19
C810 a_2375_4399# a_3609_4719# 7.71e-20
C811 a_2249_4631# a_3941_4765# 3.8e-19
C812 a_4931_2223# a_5188_2223# 0.02283f
C813 a_763_1256# a_2493_1679# 5.33e-20
C814 a_5095_1929# a_5545_2925# 0.001065f
C815 DVDD a_1907_5309# 0.161953f
C816 a_757_6281# a_1039_1942# 2.05e-20
C817 a_947_4520# a_1788_4765# 7.33e-20
C818 b2 a_4804_3311# 1.55e-19
C819 a_4533_2449# a_5023_957# 8.26e-21
C820 a_1697_743# a_3573_1501# 2.6e-19
C821 b1 a_1823_4943# 0.443739f
C822 a5 a_1400_3677# 2.2e-19
C823 a0 a_317_5095# 0.032208f
C824 a_4535_854# a_5227_3855# 0.273967f
C825 b3 a_1775_4118# 0.002193f
C826 a_3387_6031# a3 0.020133f
C827 a_5135_6031# a_3905_5719# 8.03e-19
C828 a_4751_1831# a_4847_1653# 0.173907f
C829 a_5009_6183# a_4031_5487# 0.39078f
C830 a_961_1831# P11 1.48e-19
C831 a_2235_1256# a_1697_743# 0.184839f
C832 a_763_1256# a_1865_749# 1.18e-21
C833 a_259_1831# a_527_957# 4.65e-20
C834 a_3931_4221# a_1823_4943# 0.004602f
C835 a_3517_5487# a_4115_5853# 3.25e-19
C836 a_763_1256# a_1823_3855# 1.77e-19
C837 a_4625_749# a_2980_1135# 0.011361f
C838 a_3571_2767# a_4456_1501# 7.33e-20
C839 a_6412_4007# a_1692_4399# 0.018933f
C840 a_3537_1367# a_6173_1135# 7.62e-21
C841 a1 a_3827_6031# 0.008922f
C842 a_1823_3855# a_2459_4765# 6.8e-20
C843 a_1236_2223# a_2045_2223# 3.07e-21
C844 a0 a_1079_4765# 0.006306f
C845 a_4805_2767# a_2341_2455# 3.73e-19
C846 a1 a_1079_4399# 0.004416f
C847 a_4483_4943# a_3847_3855# 2.93e-22
C848 a_2249_4631# a_2327_4520# 0.946232f
C849 a_2375_4399# a_2688_5309# 6.51e-20
C850 a_2375_3311# a_2045_2223# 7.04e-20
C851 a_2327_3432# a_2467_2223# 1.58e-19
C852 a_6644_4943# a_6412_5719# 0.008072f
C853 a_1421_2919# a_1692_4399# 1.41e-21
C854 a_763_1256# a4 4.73e-19
C855 a_2327_3432# a_995_4399# 1.05e-19
C856 a_2235_1256# a_3297_1679# 0.007028f
C857 a_2263_6941# a_1775_6696# 0.014947f
C858 a_2375_3311# a_1037_4625# 0.011786f
C859 a_3523_3030# a_3827_2045# 9.19e-20
C860 a_3813_3543# a_3537_1367# 1.29e-20
C861 a_481_6281# b3 6.31e-21
C862 P7 a_5289_1433# 4.73e-19
C863 a_3261_6183# a_4252_6397# 1.05e-19
C864 a2 a_3847_3855# 0.008002f
C865 a_4456_6941# a_3983_5608# 3.71e-20
C866 a_3983_4520# a_4351_5206# 0.010946f
C867 a_3799_4118# a_4115_5853# 5.86e-20
C868 a_4073_4625# a_4471_5853# 1e-20
C869 a_3571_2767# a_4528_1135# 2.96e-19
C870 b3 a_3517_5807# 1.3e-19
C871 a_1125_3017# a_1457_3133# 8.16e-20
C872 a_4399_4943# a_5653_5095# 0.844483f
C873 a_1823_4943# a_5779_4943# 0.730719f
C874 a0 a_2193_5853# 5.11e-20
C875 a_2263_4943# P5 0.023012f
C876 a_3072_4399# a_5821_5101# 3.17e-20
C877 P2 a_627_5487# 0.005795f
C878 a3 a_1631_3133# 9.97e-19
C879 DVDD a_6828_1679# 1.4e-19
C880 a_763_1256# a_1527_2045# 0.00387f
C881 b2 a_2320_6031# 2.07e-19
C882 a_501_5719# a_2248_6031# 0.006146f
C883 a_481_6031# DVDD 2.31e-19
C884 a_5009_6183# a_6219_5309# 4.21e-19
C885 a_5135_6031# a_5863_5309# 3.04e-20
C886 a_2520_3855# a_3076_1501# 3.16e-19
C887 a3 a_975_3677# 0.009176f
C888 a_2243_1929# a_2493_1929# 0.025037f
C889 a_1784_1679# a_395_854# 5.89e-19
C890 a_2980_5487# DVDD 0.90488f
C891 a_1987_2767# a_573_4105# 0.045338f
C892 DVDD a_2193_1135# 4.94e-19
C893 a_1455_6031# P2 0.050602f
C894 a0 a_3471_6031# 3.51e-19
C895 a_883_957# a_443_591# 0.003858f
C896 DVDD a_3747_1501# 0.035628f
C897 a5 a_5173_3631# 1.49e-19
C898 b0 a_4896_4765# 1.1e-20
C899 a_984_6183# a_883_5309# 4.96e-19
C900 a_2244_2767# a_1865_4013# 4.54e-19
C901 DVDD a_6296_2767# 3.79e-19
C902 a_5837_1831# a_4709_1929# 2.17e-19
C903 b2 a_3168_3677# 2.16e-19
C904 a_2263_4221# a_1823_4943# 0.005232f
C905 a_1039_1942# a_1987_2767# 0.036295f
C906 a_3537_6807# a_3517_5487# 0.152213f
C907 a_1039_1942# a_1251_1501# 6.44e-19
C908 a_961_1831# a_469_1929# 7.11e-19
C909 a_849_3017# a_849_2767# 0.009374f
C910 a_1039_1942# a_573_2767# 3.3e-21
C911 a_3573_1135# a_2980_1135# 3.8e-20
C912 a_1788_4399# a_1692_4399# 0.005069f
C913 a_5667_4221# a_5227_3855# 0.003887f
C914 a_5587_3133# a_5227_3855# 0.03465f
C915 a_1733_3855# a_1823_3855# 0.006958f
C916 a_1907_3855# a_1865_4013# 0.033252f
C917 a_883_4943# a_1236_4943# 2.18e-19
C918 b3 a_317_743# 5.05e-19
C919 a_5311_3855# a_3847_3855# 2.71e-20
C920 a4 a_1987_3133# 6.37e-20
C921 a_1497_6189# a_3517_5487# 2.08e-21
C922 a_5137_3855# a_5227_3855# 0.006958f
C923 a_2325_5713# b2 0.155821f
C924 a_2688_591# a_443_591# 8.7e-21
C925 a5 a_1775_4118# 0.255482f
C926 DVDD a_1457_3133# 4.94e-19
C927 a_1775_6696# a_3905_5719# 2.39e-20
C928 P1 a_883_4943# 0.023012f
C929 a_259_1831# a_301_1929# 0.00789f
C930 a_4943_1653# a_2341_2455# 6.51e-19
C931 a2 a_2248_6031# 1.94e-19
C932 a_3799_4118# a_3537_6807# 6.04e-20
C933 a_5923_2223# a_3663_1135# 0.00159f
C934 a_4804_3677# a_3072_3311# 4.57e-21
C935 a_4575_2223# a_4751_1831# 0.001457f
C936 a_3332_2223# a_1697_743# 4.29e-21
C937 a2 a_4544_3855# 0.264579f
C938 a4 a_6020_3855# 1.91e-19
C939 a_4268_2767# a_4364_3133# 0.004869f
C940 a_4011_3133# a_4436_3133# 1.31e-19
C941 a_757_6281# a_1435_4765# 0.044609f
C942 b4 a_4728_4399# 0.109203f
C943 a_3523_3030# b3 9.81e-19
C944 a_485_749# a_1308_957# 2.02e-19
C945 a_1328_3677# a_685_1367# 2.96e-20
C946 a_395_854# a_1733_957# 8.16e-20
C947 a_3261_6183# a_3573_6575# 2.87e-20
C948 a_4457_743# a_5289_1433# 0.00279f
C949 a_4943_1653# a_2980_1135# 2.12e-20
C950 b0 a_3148_5487# 7.49e-21
C951 a_2157_5719# a_3148_5853# 0.001078f
C952 a_5135_6031# a_2249_4631# 2.54e-20
C953 a_1455_6031# a_4073_4625# 2.62e-21
C954 a_6173_1135# a_5075_1148# 0.001148f
C955 a_5009_6183# a_2375_4399# 0.002892f
C956 a_2980_5487# a_3983_4520# 4.53e-21
C957 a_984_6183# b2 0.039103f
C958 a_481_6281# a5 0.116863f
C959 a_2327_3432# a_2341_2455# 0.002296f
C960 a_5689_4943# a_5653_5095# 7.07e-19
C961 a_5863_4943# a_4399_4943# 0.018413f
C962 a_2263_4943# a_1823_6575# 0.045338f
C963 b4 a_3072_3311# 0.037824f
C964 a_5345_1929# a_1775_854# 0.055726f
C965 P9 a_485_749# 0.132682f
C966 P10 a_395_854# 0.024503f
C967 DVDD a_4364_3133# 5.04e-19
C968 a_259_1831# a_685_1367# 0.730814f
C969 a2 a_443_591# 3.16e-22
C970 P3 a_627_5487# 0.073465f
C971 a3 a_3517_5487# 0.0141f
C972 a_4493_591# a_1865_749# 0.006958f
C973 a_5023_591# a_395_854# 1.94e-20
C974 b1 a_1308_5309# 1.78e-19
C975 a_355_1653# a_573_4105# 8.68e-20
C976 a_317_2455# a_849_4105# 1.72e-21
C977 b4 a_4379_3311# 0.001652f
C978 DVDD a_353_4943# 6.47e-19
C979 b0 a_1508_1135# 1.01e-19
C980 a_2327_4520# a_1823_4943# 0.066789f
C981 a_248_4631# a_849_4105# 0.063317f
C982 a_947_4520# a_573_4105# 3.46e-20
C983 b1 a_3240_4399# 1.07e-19
C984 a_2375_3311# a_1775_4118# 0.034707f
C985 a_2907_2223# a_2520_3855# 0.005669f
C986 a_3387_6031# a_4621_6031# 2.21e-19
C987 DVDD P2 0.155489f
C988 a_2520_3855# a_395_854# 0.099544f
C989 a_5943_3133# a_4544_3855# 0.011853f
C990 a_2045_2223# a_849_3017# 5.29e-19
C991 a_355_1653# a_1039_1942# 5.71e-19
C992 a_4709_1929# a_3571_2767# 1.55e-19
C993 a_2467_2223# a_1421_2919# 0.001452f
C994 a_1697_743# a_2244_2767# 0.038423f
C995 a_5311_3855# a_4544_3855# 6.14e-19
C996 a_5653_5095# a_4351_5206# 2.48e-20
C997 a_995_4399# a_1421_2919# 0.002027f
C998 a_947_4520# a_1039_1942# 9.66e-22
C999 a_4728_4399# a_4031_5487# 0.020904f
C1000 a_5837_1831# a_3891_3432# 0.004379f
C1001 a_1037_4625# a_849_3017# 0.002439f
C1002 b5 a_4073_4625# 0.188895f
C1003 a_757_6281# a_1079_4399# 0.012139f
C1004 b4 a_1784_1679# 2.09e-21
C1005 a_4287_3855# a_4712_3855# 8.12e-20
C1006 a_3891_3432# a_5667_3855# 0.002441f
C1007 a4 a_5587_2767# 0.004648f
C1008 a1 a_2285_4765# 1.46e-19
C1009 DVDD a_619_3311# 0.251313f
C1010 a_995_4399# a_443_4943# 5.26e-19
C1011 a_1508_1135# a_2193_1501# 1.47e-19
C1012 a_1775_4118# a_1676_1501# 3.01e-20
C1013 a_3571_2767# a_3072_3311# 3.14e-19
C1014 a_4732_3677# a_4544_3855# 7.38e-19
C1015 a_1125_3017# a_1865_4013# 1.3e-19
C1016 a_4011_2767# a_2235_1256# 1.14e-20
C1017 a_3164_2223# a_3847_3855# 0.02156f
C1018 a_4804_3677# a_3891_3432# 2.11e-19
C1019 a3 a_1823_3855# 0.068973f
C1020 a_2815_3677# a_3072_3311# 0.024184f
C1021 a5 a_317_743# 2.07e-19
C1022 DVDD a_1308_957# 5.09e-19
C1023 a_3072_3311# a_4031_5487# 2.14e-19
C1024 a_1907_6575# a0 0.003109f
C1025 a_5227_3855# a_2283_5487# 5.79e-20
C1026 a_527_5309# a_883_5309# 0.009846f
C1027 b5 a_1865_4013# 0.070854f
C1028 P4 a_2520_6575# 0.050448f
C1029 a_1895_6031# a_1823_6575# 0.003391f
C1030 a_1365_6031# a_627_5487# 2.22e-19
C1031 a3 a_1907_4943# 0.034577f
C1032 b1 a_3537_6807# 4.12e-21
C1033 a_3799_4118# a_4011_3133# 7.43e-21
C1034 a_4073_4625# a_4268_2767# 1.16e-20
C1035 a4 a_5503_2767# 0.047177f
C1036 a_3941_4399# a_3072_4399# 8.16e-20
C1037 a_1769_3631# a_1421_2919# 5.87e-20
C1038 a_501_5719# a0 0.043085f
C1039 a_6020_3855# a_5779_4943# 1.82e-19
C1040 b2 b3 0.034816f
C1041 a1 P5 0.001123f
C1042 DVDD P9 0.213317f
C1043 a_5448_591# P7 0.00792f
C1044 a3 a4 0.251703f
C1045 a4 a_6412_5719# 1.11e-19
C1046 a_1497_6189# a_1539_6031# 0.033252f
C1047 b4 a_4287_4221# 0.0029f
C1048 a_1455_6031# a_1365_6031# 0.006958f
C1049 a5 a_3523_3030# 0.015876f
C1050 a_3387_6031# a_4180_6397# 4.35e-21
C1051 a_2980_5487# a_4252_6397# 2.96e-19
C1052 a_1497_6189# b1 0.012569f
C1053 a_685_1367# a_1508_1135# 0.177721f
C1054 a_5575_6031# a_4031_5487# 0.009449f
C1055 a_443_4943# a_2235_5608# 0.002976f
C1056 b4 a_3891_3432# 0.057139f
C1057 a_4667_591# DVDD 0.001413f
C1058 b2 a_3076_5487# 1.18e-20
C1059 a_4268_2767# a_1865_4013# 0.191887f
C1060 a_3655_3133# a_3072_3311# 1.68e-20
C1061 b4 a_975_3311# 0.002305f
C1062 b2 a_1328_3311# 1.99e-20
C1063 a_1784_1679# a_3571_2767# 2.08e-19
C1064 a_1952_2045# a_1039_1942# 2.96e-19
C1065 a_4457_743# a_317_743# 0.003401f
C1066 a_1697_743# a_6756_1679# 4.57e-21
C1067 a_4751_1831# a_3663_1135# 0.199215f
C1068 DVDD a_4073_4625# 0.830516f
C1069 a1 a_3941_5853# 5.13e-19
C1070 DVDD a_1952_1679# 9.29e-21
C1071 a_995_4399# a_4712_4221# 7.35e-21
C1072 a0 a_1860_4765# 2.05e-19
C1073 a_995_4399# a_1788_4399# 2.88e-19
C1074 a_2459_4765# a_2327_4520# 0.017809f
C1075 a_995_4399# a_4287_3855# 0.045338f
C1076 a_1236_2223# a_317_743# 2.16e-20
C1077 b3 a_1788_4765# 9.12e-19
C1078 a_248_4631# a_1125_3855# 0.009374f
C1079 a_2235_1256# a_2723_1135# 0.01759f
C1080 a_5284_2589# a_3847_3855# 7.33e-20
C1081 a_5345_1929# a_5545_2925# 9.13e-20
C1082 a_763_1256# a_395_2344# 0.001206f
C1083 a0 a_4483_4943# 0.003513f
C1084 a_4839_4943# a_2417_4625# 1.83e-20
C1085 a_6403_1679# a_5779_4943# 0.005557f
C1086 DVDD a_1865_4013# 0.771982f
C1087 a_4943_1653# a_4636_3311# 5.5e-20
C1088 a_4751_1831# a_4103_1501# 1.46e-20
C1089 a_685_1367# a_527_957# 6.74e-19
C1090 b2 a_5081_2767# 7.16e-22
C1091 a_5009_6183# a_3072_4399# 0.130809f
C1092 a_5545_2925# a_5227_3855# 0.705599f
C1093 a_3387_6031# a_4399_4943# 0.001128f
C1094 a1 a_6092_4221# 1.98e-20
C1095 a_2689_6031# a_2235_5608# 7.17e-20
C1096 a0 a2 0.375435f
C1097 DVDD P3 0.318128f
C1098 a1 a_3168_4399# 5.02e-20
C1099 a_1037_4625# a_1329_6183# 1.22e-21
C1100 a_3164_2223# a_4544_3855# 0.003401f
C1101 b1 a3 0.376424f
C1102 DVDD a_3849_3311# 4.94e-19
C1103 P5 a_2417_4625# 8.37e-21
C1104 a_3571_2767# a_3891_3432# 0.004062f
C1105 a_1697_743# a_485_749# 0.695881f
C1106 DVDD a_5045_6031# 1.57e-19
C1107 a_1775_854# a_4252_1679# 0.001172f
C1108 a_317_743# a_1676_1501# 6.4e-20
C1109 a_3261_6183# a_2157_5719# 0.005191f
C1110 a_5587_2767# a_5779_4943# 0.002486f
C1111 a_3891_3432# a_4031_5487# 0.005223f
C1112 a_5227_3855# a_5923_1135# 1.03e-20
C1113 a_1823_6575# a_2520_3855# 1.25e-20
C1114 a_2327_3432# a_4636_3311# 4.96e-21
C1115 a_1421_2919# a_2341_2455# 7.1e-19
C1116 a_2375_3311# a_3523_3030# 1.07317f
C1117 a_6644_4943# a_4399_4943# 8.69e-20
C1118 b5 a_2688_3855# 3.79e-20
C1119 a2 a_2723_5487# 0.005413f
C1120 a_6572_4943# a_5653_5095# 5.43e-19
C1121 P7 a_4535_854# 0.074946f
C1122 a_4103_6575# a_3537_6807# 0.019601f
C1123 a_3747_6575# a_627_5487# 0.032924f
C1124 a_5081_2767# a_4535_854# 4.74e-19
C1125 a_1308_591# a_443_591# 3.62e-19
C1126 a_1697_743# a_1125_3017# 0.004893f
C1127 b4 a_2520_3855# 0.031674f
C1128 a_3517_5487# a_3148_5853# 2.22e-19
C1129 a_2688_957# a_1865_749# 2.08e-19
C1130 a_1508_1135# a_1692_4399# 0.001331f
C1131 a_5376_591# a_4535_854# 7.33e-20
C1132 DVDD a_1171_2045# 0.149777f
C1133 a_1365_6397# a_481_6281# 3.29e-20
C1134 a_553_1679# a_1421_2919# 5.44e-19
C1135 b5 a_1697_743# 6.44e-19
C1136 a_2375_4399# a_4728_4399# 0.028656f
C1137 a_3571_2767# a_4860_1367# 4.04e-19
C1138 a_995_4399# a_905_4765# 0.006958f
C1139 a_4709_1929# a_5188_2223# 3.52e-20
C1140 a_3983_4520# a_4073_4625# 0.787803f
C1141 a1 a_2520_6575# 0.0077f
C1142 a_3609_4399# a_3799_4118# 0.766867f
C1143 a_947_4520# a_1435_4765# 0.005898f
C1144 a_501_5719# a_1067_5487# 0.013375f
C1145 a_2980_5487# a_3573_6575# 9.68e-21
C1146 a_1455_6031# a_3747_6575# 7.33e-20
C1147 a_3387_6031# a_3261_6183# 0.812111f
C1148 a_5448_591# a_4457_743# 3.15e-19
C1149 a_4471_5853# a_4896_5853# 8.12e-20
C1150 a_3537_1367# a_2467_2223# 0.117162f
C1151 a_3827_2045# a_1775_854# 0.006339f
C1152 a1 a_1823_6575# 0.001702f
C1153 a_4351_5206# a_4824_5853# 0.005644f
C1154 a_501_5719# a_1067_5853# 0.050499f
C1155 a_5503_2767# a_5779_4943# 0.26869f
C1156 b2 a_1420_5853# 8e-21
C1157 a_5779_4943# a_6412_5719# 0.054945f
C1158 a_849_3017# a_1775_4118# 0.029034f
C1159 a_3537_1367# a_4252_2045# 0.007824f
C1160 a_3571_2767# a_3827_1679# 0.00564f
C1161 a_2325_5713# a_2283_5487# 0.263653f
C1162 a5 b2 0.447007f
C1163 a1 b4 0.15562f
C1164 b5 a_5821_5101# 4.36e-20
C1165 a_553_1679# a_469_1679# 0.002065f
C1166 a0 a_5575_6397# 1.12e-20
C1167 a2 a_4824_4399# 1.1e-19
C1168 a_2375_4399# a_3072_3311# 9.15e-20
C1169 a_3983_4520# a_1865_4013# 0.00441f
C1170 DVDD a_527_2223# 0.162601f
C1171 a_317_5095# a_443_4943# 0.745483f
C1172 a5 a_895_1135# 3.7e-19
C1173 a_1697_743# a_4268_2767# 0.003989f
C1174 a_3240_4399# a_2327_4520# 1.9e-19
C1175 a_3168_4399# a_2417_4625# 2.81e-19
C1176 a_1308_2223# a_685_1367# 0.00776f
C1177 DVDD a_3757_4221# 4.94e-19
C1178 a_3072_3311# a_849_4105# 0.064333f
C1179 b1 a_4824_5487# 3.87e-20
C1180 a_1079_4765# a_443_4943# 5.35e-19
C1181 a4 a_5923_2223# 0.003937f
C1182 b4 a_4115_4765# 3.1e-19
C1183 a_2263_4943# a_849_4105# 1.14e-19
C1184 a4 a_3609_4399# 1.01e-19
C1185 a_1907_591# a_485_749# 0.066113f
C1186 a5 a_4535_854# 4.76e-19
C1187 a_2616_591# a_317_743# 2.62e-19
C1188 a_3471_2045# a_3164_2223# 2.23e-20
C1189 a_4535_854# a_3747_1135# 1.03e-19
C1190 a_3571_2767# a_2520_3855# 1.67e-21
C1191 a3 a_2263_4221# 0.002101f
C1192 P6 a_1692_4399# 7.39e-19
C1193 a_2815_3677# a_2520_3855# 0.003914f
C1194 a_4379_3311# a_849_4105# 4.87e-20
C1195 a_5837_1831# a_5095_1929# 0.01285f
C1196 a_297_3017# a_619_3311# 0.036213f
C1197 DVDD a_1697_743# 1.03383f
C1198 a_395_2344# a_445_3311# 0.0069f
C1199 a_1907_5309# a_2263_5309# 0.009846f
C1200 a_984_6183# a_2283_5487# 6.6e-20
C1201 b5 a_1907_4221# 0.001772f
C1202 a_5009_6183# a_5264_4943# 0.00792f
C1203 a3 a_711_5487# 1.1e-21
C1204 a_2815_3311# a_3072_3311# 0.02283f
C1205 a2 a_1067_5487# 3.02e-19
C1206 a_3240_3311# a_1865_4013# 1.78e-19
C1207 a_4528_6941# b0 1.82e-19
C1208 a_4011_2767# a_2244_2767# 7.3e-20
C1209 P7 a_5376_957# 0.004869f
C1210 a_947_4520# a_1079_4399# 0.035689f
C1211 a_1784_1679# a_1171_1679# 3.09e-19
C1212 a_6572_5309# a_5779_4943# 4.35e-21
C1213 a_1823_6575# a_2417_4625# 1.38e-19
C1214 b4 a_883_2223# 4.43e-19
C1215 DVDD a_4493_957# 5.13e-19
C1216 a_3983_5608# a_4896_5487# 1.9e-19
C1217 DVDD a_5821_5101# 0.889196f
C1218 b4 a_2417_4625# 3.99e-21
C1219 a1 a_4031_5487# 0.106978f
C1220 a_4457_743# a_4535_854# 1.29704f
C1221 b2 a_2375_3311# 0.199389f
C1222 a_1823_6575# a_2367_5487# 4.31e-19
C1223 a_2327_3432# P11 9.3e-22
C1224 a_2341_2455# a_4709_1679# 2.67e-20
C1225 a_3164_2223# a_4471_4765# 1.47e-21
C1226 a_297_4105# a_317_743# 0.001303f
C1227 b3 a_1775_854# 1.29e-21
C1228 b1 a_3609_4399# 3.43e-19
C1229 a_4625_749# a_5873_1679# 0.007856f
C1230 a_3387_6031# a_4351_5206# 1.73e-20
C1231 a_883_2589# a_1236_2589# 2.18e-19
C1232 a_4471_4765# a_3905_5719# 3.23e-21
C1233 a_3609_4399# a_3931_4221# 1.04e-19
C1234 a_4073_4625# a_2249_3543# 1.39e-19
C1235 a_2375_4399# a_4287_4221# 1.72e-20
C1236 a_4575_2589# a_3537_1367# 2.82e-20
C1237 a_5188_2223# a_3891_3432# 0.002526f
C1238 a_2616_6575# a_1775_6696# 2.73e-19
C1239 b0 a_1692_4399# 0.001324f
C1240 a_4931_2223# b5 2.91e-20
C1241 a_2375_4399# a_3891_3432# 0.003612f
C1242 DVDD a_1907_4221# 0.14978f
C1243 a2 a_4943_1653# 1.6e-19
C1244 a_3747_6575# DVDD 0.251177f
C1245 a_3813_3543# a_1692_4399# 1.82e-21
C1246 b3 a_573_4105# 0.394891f
C1247 a_4636_3311# a_6412_4007# 6.89e-20
C1248 DVDD a_1907_591# 0.00143f
C1249 a_2551_2223# a_2327_3432# 9.61e-21
C1250 a_3537_1367# a_2341_2455# 0.007499f
C1251 b1 a_3148_5853# 6.67e-20
C1252 a_757_6281# a_1236_5309# 1.59e-19
C1253 a_2459_3311# a_2520_3855# 0.00408f
C1254 a_3891_3432# a_849_4105# 4.57e-19
C1255 a_2249_3543# a_1865_4013# 0.160518f
C1256 a_219_1929# a_469_1679# 0.007234f
C1257 a_1697_743# a_1880_1679# 8.45e-21
C1258 b4 a_4471_4399# 0.007323f
C1259 a1 a_6219_5309# 8.13e-19
C1260 a_2263_3855# a_1823_3855# 0.032537f
C1261 a_2907_2589# a_3164_2223# 0.023012f
C1262 b3 a_1039_1942# 0.030367f
C1263 a_763_1256# a_1631_2767# 6.67e-21
C1264 a_2815_3677# a_2417_4625# 1.06e-20
C1265 a_4483_5309# a_2283_5487# 0.129605f
C1266 a0 a_3905_5719# 0.054947f
C1267 a3 a_2327_4520# 0.318868f
C1268 b1 a_3168_3311# 4.72e-20
C1269 a_3537_1367# a_2980_1135# 0.007011f
C1270 a_5923_2223# a_5779_4943# 0.017663f
C1271 b3 a_2283_5487# 0.016179f
C1272 a5 a_5137_3855# 3.7e-19
C1273 a_4931_2223# a_4268_2767# 0.011819f
C1274 a3 a_395_2344# 0.036491f
C1275 a_3241_6895# a_2157_5719# 0.009374f
C1276 a_4751_1831# a_1865_749# 9.55e-20
C1277 a_3799_4118# a_4399_4943# 0.002927f
C1278 a_905_4765# a_317_5095# 1.73e-19
C1279 a_4073_4625# a_5653_5095# 0.003173f
C1280 a_4728_4399# a_3072_4399# 0.00356f
C1281 a_4847_1653# a_1865_4013# 0.034041f
C1282 a_4535_854# a_5023_957# 0.029194f
C1283 a_395_854# a_1251_1501# 6.11e-20
C1284 a4 a_1401_3855# 5.39e-19
C1285 P7 a_1775_854# 5.19e-21
C1286 a_485_749# a_895_1501# 4.98e-20
C1287 a_2045_2223# a_1775_4118# 0.035825f
C1288 a_481_6281# a_1329_6183# 0.853187f
C1289 a_1037_4625# a_1775_4118# 0.010396f
C1290 a_995_4399# a_1508_1135# 0.009518f
C1291 a4 a_2263_3855# 7.19e-20
C1292 a_3076_5487# a_2283_5487# 4.35e-21
C1293 a_3148_5487# a_2235_5608# 2.34e-19
C1294 a_3261_6183# a_3517_5487# 0.117434f
C1295 a5 a_4379_3677# 0.003677f
C1296 a_4457_743# a_5376_957# 7.63e-21
C1297 a4 a_4751_1831# 0.00174f
C1298 a_3072_3311# a_3072_4399# 3.62e-19
C1299 DVDD a_4931_2223# 0.148241f
C1300 a_3847_3855# a_1823_4943# 0.010477f
C1301 a_961_1831# a_2243_1929# 0.003289f
C1302 a_2980_5487# a_2157_5719# 0.150491f
C1303 DVDD a_6219_4943# 0.012355f
C1304 a_2325_5713# a_2367_5853# 0.036497f
C1305 a_2616_4943# a_1823_4943# 2.2e-19
C1306 b3 a_1125_2767# 6.04e-20
C1307 a_757_6281# a_1823_6575# 0.001199f
C1308 a_5135_6031# a_3537_6807# 0.001176f
C1309 a_6173_2223# a_5545_2925# 4.67e-20
C1310 a_2375_4399# a_2520_3855# 0.003935f
C1311 a_757_6281# b4 3.95e-21
C1312 a_481_6281# a_1037_4625# 2.19e-19
C1313 a_3261_6183# a_3799_4118# 1.41e-19
C1314 b0 a_5045_6397# 2.87e-20
C1315 a_1769_3631# a_1508_1135# 7.19e-20
C1316 a4 a_4399_4943# 1.62e-19
C1317 a_2235_1256# a_1784_1679# 0.802816f
C1318 a_1508_1135# a_2235_5608# 1.02e-20
C1319 a_4839_5309# a_5264_5309# 1.31e-19
C1320 a_3747_1501# a_3663_1135# 0.071235f
C1321 a_4011_2767# b5 7.38e-21
C1322 a_2980_5487# a_3387_6031# 0.185459f
C1323 a_2325_5713# a_3827_6031# 2.41e-20
C1324 a_259_1831# a_553_1679# 0.095029f
C1325 a_1455_6031# a_5009_6183# 2.87e-20
C1326 a_6173_2223# a_5923_1135# 2.21e-20
C1327 a_849_4105# a_2520_3855# 0.041236f
C1328 DVDD a_2688_5309# 4.72e-19
C1329 DVDD a_2045_2543# 3.97e-20
C1330 a_2327_3432# a_2815_4399# 8.06e-20
C1331 a5 a_1775_854# 1.23e-19
C1332 a_3523_3030# a_4533_2449# 1.62e-20
C1333 a1 a_2375_4399# 1.73973f
C1334 b3 a_849_3855# 4.83e-19
C1335 a_2244_2767# a_1457_2767# 2.89e-20
C1336 b3 a_3941_5487# 4.66e-20
C1337 a_3332_2589# a_2341_2455# 1.72e-19
C1338 a5 a_997_1679# 7.45e-20
C1339 a_1775_854# a_721_1135# 4.45e-21
C1340 DVDD a_4896_5853# 1.47e-19
C1341 a_3747_1501# a_4103_1501# 0.008475f
C1342 a_2688_3855# a_2249_3543# 1.87e-19
C1343 a_4457_743# a_5345_1679# 9.51e-20
C1344 a5 a_573_4105# 0.140024f
C1345 a1 a_849_4105# 0.001306f
C1346 b2 a_297_4105# 4e-20
C1347 a_3523_3030# a_3849_3677# 0.00697f
C1348 a_3813_3543# a_4023_3677# 0.04028f
C1349 a_4636_3311# a_3240_3677# 1.06e-21
C1350 a_2815_3311# a_2520_3855# 3.69e-19
C1351 DVDD a_895_1501# 0.034638f
C1352 a_5023_957# a_5376_957# 2.18e-19
C1353 a_4011_2767# a_4268_2767# 0.024253f
C1354 b2 a_3517_4943# 7.79e-20
C1355 b0 a_1733_6941# 1.46e-19
C1356 a1 a_3076_5853# 2.28e-19
C1357 a_2375_4399# a_4115_4765# 0.00295f
C1358 a_2249_4631# a_4471_4765# 0.004807f
C1359 a_3609_4399# a_3941_4765# 6.52e-19
C1360 a_3983_4520# a_3609_4719# 1.96e-20
C1361 a_5356_2223# a_5188_2223# 0.007578f
C1362 P1 a_1329_6183# 3.66e-20
C1363 DVDD a_297_2767# 2.84e-19
C1364 DVDD a_2616_5309# 2.76e-19
C1365 b2 a_849_3017# 0.002243f
C1366 a_984_6183# a_1079_4399# 1.13e-20
C1367 a5 a_1039_1942# 0.079912f
C1368 a_4457_743# a_1775_854# 0.043052f
C1369 a_355_1653# a_395_854# 5.88e-19
C1370 b1 a_4399_4943# 0.037959f
C1371 a5 a_2285_3677# 5.21e-19
C1372 a_2045_2223# a_317_743# 4.35e-19
C1373 a_317_2455# a_485_749# 2.16e-19
C1374 a_501_5719# a_443_4943# 0.782641f
C1375 a5 a_2283_5487# 4.94e-21
C1376 a_5135_6031# a_6412_5719# 2.9e-19
C1377 a_4847_1653# a_1697_743# 0.093039f
C1378 a_5009_6183# b5 8.98e-19
C1379 DVDD a_3941_4399# 4.94e-19
C1380 a_4544_3855# a_1823_4943# 0.013271f
C1381 DVDD a_4011_2767# 0.009405f
C1382 a_3517_5487# a_4351_5206# 0.001864f
C1383 a_1865_4013# a_3240_4765# 7.64e-20
C1384 a1 a_4252_6031# 8.77e-20
C1385 a_3891_3432# a_3072_4399# 2.51e-19
C1386 a_317_2455# a_1125_3017# 7.82e-21
C1387 a_4575_2223# a_1865_4013# 0.008714f
C1388 a_2243_1929# a_443_591# 1.17e-21
C1389 a_2341_2455# a_1508_1135# 2.63e-20
C1390 a_3891_3432# a_6403_2045# 2.37e-19
C1391 a_5075_1148# a_2980_1135# 0.030066f
C1392 b3 a_1435_4765# 0.035806f
C1393 b5 a_317_2455# 4.6e-20
C1394 a0 a_2249_4631# 0.648068f
C1395 a_2375_4399# a_2417_4625# 0.23765f
C1396 a_3609_4399# a_2327_4520# 0.005435f
C1397 b0 a_995_4399# 0.001098f
C1398 a_2375_3311# a_1775_854# 7.37e-19
C1399 a_4751_1831# a_5779_4943# 0.002251f
C1400 b5 a_248_4631# 0.025078f
C1401 P1 a_1037_4625# 8.37e-21
C1402 a_619_3311# a_409_3543# 0.01793f
C1403 a_3813_3543# a_995_4399# 2.9e-19
C1404 a_883_591# a_1308_591# 8.12e-20
C1405 a_553_1679# a_1508_1135# 0.01755f
C1406 a_763_1256# a_961_1831# 0.72656f
C1407 a_2235_1256# a_3827_1679# 0.028437f
C1408 a_2616_6941# a_1775_6696# 3.42e-19
C1409 a_1508_1135# a_2980_1135# 1.69e-19
C1410 b4 a_573_2767# 2.52e-19
C1411 a_849_4105# a_2417_4625# 0.003508f
C1412 a_5503_2767# a_6173_1455# 1.6e-19
C1413 a2 a_6412_4007# 5.28e-22
C1414 a5 a_1125_2767# 2.8e-19
C1415 a_3799_4118# a_4351_5206# 0.0059f
C1416 a_3537_6807# a_1775_6696# 0.692799f
C1417 a_3261_6183# b1 8.65e-19
C1418 a_2249_4631# a_2723_5487# 3.43e-19
C1419 a_2375_3311# a_573_4105# 0.001236f
C1420 a_5095_1929# a_5188_2223# 4.09e-19
C1421 a_4399_4943# a_5779_4943# 0.184708f
C1422 a_5653_5095# a_5821_5101# 0.51713f
C1423 a_2688_4943# P5 0.00792f
C1424 a_2248_6397# a_1775_6696# 9.12e-20
C1425 a_763_1256# a_1880_2045# 4.35e-21
C1426 a_6756_2045# a_5779_4943# 2.59e-19
C1427 a_259_1831# a_219_1929# 0.234779f
C1428 a_1497_6189# a_1775_6696# 0.009693f
C1429 a1 a_3827_6397# 0.002553f
C1430 a_2235_1256# a_3297_2045# 0.006823f
C1431 a_2375_3311# a_1039_1942# 3.76e-19
C1432 a_2235_1256# a_2520_3855# 0.184905f
C1433 a_4709_1929# a_2244_2767# 8.51e-19
C1434 a2 a_443_4943# 0.001044f
C1435 b2 a_4533_2449# 0.002473f
C1436 a_5009_6183# DVDD 1.43994f
C1437 a_2327_3432# a_3164_2223# 3.33e-19
C1438 b0 a_2235_5608# 0.004513f
C1439 DVDD a_2723_1135# 0.237825f
C1440 a_2327_3432# a_2459_3677# 0.017809f
C1441 a_2375_3311# a_2285_3677# 0.006958f
C1442 a5 a_849_3855# 2.59e-19
C1443 a_1037_4625# a_883_5309# 8.66e-20
C1444 b3 a_3827_6031# 3.6e-19
C1445 a5 a_5545_2925# 0.002586f
C1446 a_3609_4399# a_4115_4399# 0.011205f
C1447 a_2244_2767# a_3072_3311# 2.54e-20
C1448 a_5837_1831# a_5345_1929# 7.11e-19
C1449 DVDD a_317_2455# 0.815869f
C1450 a_1733_6575# a_1329_6183# 4.34e-20
C1451 a_2340_3133# a_1823_3855# 7.92e-20
C1452 b3 a_1079_4399# 0.002478f
C1453 b2 a_3849_3677# 1.27e-19
C1454 a_2616_4221# a_1823_4943# 2.55e-19
C1455 DVDD a_248_4631# 1.22085f
C1456 a_627_5487# a_1125_6895# 1.81e-19
C1457 a_1125_3017# a_1457_2767# 1.73e-19
C1458 a_4351_5206# a_5219_6031# 3.09e-21
C1459 b1 a_3168_4765# 3.04e-19
C1460 a_2325_5713# a_2263_6575# 8.53e-21
C1461 a_4533_2449# a_4535_854# 0.261294f
C1462 a_5311_4221# a_1692_4399# 0.012091f
C1463 b2 a_1329_6183# 0.051615f
C1464 a_1895_6397# a_1329_6183# 0.011819f
C1465 a_2285_4399# a_1692_4399# 6.39e-20
C1466 a_5837_1831# a_5227_3855# 0.075018f
C1467 a_3655_2767# a_1865_4013# 3.42e-20
C1468 a_2980_5487# a_3517_5487# 0.263822f
C1469 a_5667_3855# a_5227_3855# 0.036417f
C1470 DVDD a_4528_1135# 5.34e-19
C1471 a3 a_1775_6696# 0.043982f
C1472 a_4667_591# a_3663_1135# 0.001083f
C1473 a1 a_3072_4399# 0.377795f
C1474 a_4457_743# a_5545_2925# 9.38e-20
C1475 a_1455_6031# a_757_6031# 4.55e-21
C1476 a_1775_854# a_2616_591# 7.33e-20
C1477 b0 a_5264_5309# 9.76e-20
C1478 a_3481_2767# a4 2.26e-19
C1479 a_4575_2223# a_1697_743# 0.002101f
C1480 a_763_1256# a_443_591# 0.009022f
C1481 a2 a_4712_4221# 8.98e-20
C1482 a_1784_1679# a_2244_2767# 3.44e-19
C1483 b1 a_1308_2589# 1.37e-20
C1484 a_947_4520# a_1823_6575# 8.27e-19
C1485 a_3261_6183# a_4103_6575# 0.039138f
C1486 a_2157_5719# a_1865_4013# 4.45e-22
C1487 b2 a_2045_2223# 0.006552f
C1488 b4 a_355_1653# 0.006276f
C1489 a_6005_1135# a_5923_1135# 0.006406f
C1490 a_4535_854# a_4793_1679# 7.46e-21
C1491 a_3387_6031# a_4073_4625# 5.74e-20
C1492 a_4115_4765# a_3072_4399# 0.009597f
C1493 a_5009_6183# a_3983_4520# 4.13e-20
C1494 a_757_6281# a_2375_4399# 0.003016f
C1495 a_1539_6397# a_995_4399# 1.88e-21
C1496 b2 a_1037_4625# 0.341909f
C1497 a_2980_5487# a_3799_4118# 5.63e-21
C1498 a_6173_1135# a_2980_1135# 0.010838f
C1499 b4 a_947_4520# 3.8e-21
C1500 a_2263_3855# a_2327_4520# 2.93e-20
C1501 b1 a_4351_5206# 0.475192f
C1502 P11 a_3537_1367# 3.96e-20
C1503 a_3813_3543# a_2341_2455# 0.037971f
C1504 a_5689_4943# a_5779_4943# 0.006958f
C1505 a_5863_4943# a_5821_5101# 0.033252f
C1506 a_6219_4943# a_5653_5095# 0.044609f
C1507 a_1865_4013# a_3663_1135# 0.016694f
C1508 b4 a_5227_3855# 0.008208f
C1509 a_757_6281# a_849_4105# 0.001755f
C1510 a_317_2455# a_353_2589# 4.78e-19
C1511 a_2551_2589# a_2235_1256# 3.13e-20
C1512 a_1775_4118# a_317_743# 0.006906f
C1513 a_4103_6941# a_3905_5719# 5.29e-20
C1514 a_995_4399# a_1692_4399# 0.12125f
C1515 a_297_3017# a_297_2767# 0.009728f
C1516 a_2377_2223# a_2045_2223# 8.16e-20
C1517 a_2325_5713# P5 0.003641f
C1518 a0 a_1823_4943# 0.092895f
C1519 a_2327_4520# a_4399_4943# 8.92e-20
C1520 a_2244_2767# a_3891_3432# 1.97e-19
C1521 a_2417_4625# a_3072_4399# 0.277902f
C1522 b0 a_317_5095# 0.26206f
C1523 b2 a_1400_3677# 5.85e-19
C1524 a_3261_6183# a_3941_4765# 2.23e-21
C1525 a_553_1679# a_301_1929# 6.03e-19
C1526 a_259_1831# a_883_957# 2.32e-19
C1527 a_219_1929# a_527_957# 2.18e-20
C1528 a_5135_6031# a_4621_6031# 2.8e-20
C1529 a_297_4105# a_573_4105# 0.014519f
C1530 a_961_1831# a_1604_1135# 4.63e-20
C1531 a_1697_743# a_2412_3133# 1.63e-20
C1532 a_5779_4943# a_4351_5206# 8.97e-20
C1533 b0 a_1079_4765# 1.52e-19
C1534 a_6368_3133# a_3891_3432# 9.09e-22
C1535 b5 a_4728_4399# 0.086066f
C1536 a_3891_3432# a_6092_3855# 1.67e-19
C1537 b5 a_4709_1929# 7.54e-21
C1538 a_4625_749# a_1823_4943# 0.221064f
C1539 a1 a_2815_4765# 2.78e-21
C1540 a_1508_1135# a_2723_1501# 1.28e-19
C1541 a_1775_4118# a_2367_1501# 0.070708f
C1542 a_2327_3432# a_2249_4631# 3.77e-20
C1543 a_849_3017# a_573_4105# 1.39799f
C1544 a_685_1367# a_2341_2455# 1.29e-19
C1545 a_5503_2767# a_3847_3855# 0.003373f
C1546 a_1039_1942# a_297_4105# 1.24e-20
C1547 a_1125_3017# a_3072_3311# 3.03e-20
C1548 a_4533_2449# a_4379_3677# 2.09e-20
C1549 a_1692_4399# a_2235_5608# 6.41e-20
C1550 a_481_6281# P1 7.14e-20
C1551 a_5227_3855# a_4031_5487# 0.154031f
C1552 a_3261_6183# a_2327_4520# 1.98e-19
C1553 P10 a_2244_2767# 1.57e-19
C1554 a_2244_2767# a_3827_1679# 0.044609f
C1555 b5 a_3072_3311# 0.075872f
C1556 a_2320_6031# a_1823_6575# 2.58e-20
C1557 a3 a_2616_4943# 0.001197f
C1558 a_553_1679# a_685_1367# 0.026879f
C1559 DVDD a_1125_6895# 7.52e-20
C1560 b0 a_2193_5853# 5.97e-20
C1561 a_685_1367# a_2980_1135# 1.85e-20
C1562 a4 a_1457_3133# 3.66e-20
C1563 a_849_3017# a_1039_1942# 0.157282f
C1564 a_1421_2919# a_3164_2223# 0.002749f
C1565 a_4471_4399# a_3072_4399# 9.99e-19
C1566 a_6277_4719# a_5821_5101# 5.57e-19
C1567 a_2459_3677# a_1421_2919# 1.21e-19
C1568 a_4709_1929# a_4268_2767# 2.66e-19
C1569 b4 a_4640_4221# 3.02e-19
C1570 a_1455_6031# a_1895_6031# 0.029056f
C1571 a1 a_619_3677# 1.48e-19
C1572 a3 a_961_1831# 0.011383f
C1573 a_4575_2223# a_4931_2223# 0.009846f
C1574 a_1784_1679# a_485_749# 1.54e-19
C1575 a_2980_5487# b1 0.001725f
C1576 a_5863_4943# a_6219_4943# 0.008475f
C1577 a_2235_1256# a_2263_591# 5.5e-20
C1578 a_4011_3133# a_3847_3855# 0.002095f
C1579 a_2244_2767# a_2520_3855# 0.320997f
C1580 a_4268_2767# a_3072_3311# 8.07e-21
C1581 a_4436_3133# a_1865_4013# 3.01e-19
C1582 a_1236_957# a_443_591# 4.35e-21
C1583 a_1784_1679# a_1125_3017# 9.34e-19
C1584 a_1697_743# a_3663_1135# 0.484525f
C1585 DVDD a_4728_4399# 0.927342f
C1586 a_1329_6183# a_1907_6941# 2.43e-20
C1587 a_4533_2449# a_1775_854# 0.246342f
C1588 DVDD a_4709_1929# 1.02216f
C1589 a_553_1679# a_2263_957# 1.25e-20
C1590 a_995_4399# a_5311_4221# 5.5e-20
C1591 a_1037_4625# a_2459_4399# 7.01e-20
C1592 a_2325_5713# a_2520_6575# 0.002308f
C1593 a_5587_2767# a_4544_3855# 0.04028f
C1594 a_2815_4765# a_2417_4625# 0.045338f
C1595 a_297_3017# a_317_2455# 0.007894f
C1596 a_3168_4765# a_2327_4520# 7.33e-20
C1597 a0 a_2459_4765# 0.002333f
C1598 b3 a_2285_4765# 7.33e-19
C1599 a_297_3017# a_248_4631# 6.48e-20
C1600 a_1039_1942# a_849_2767# 5.94e-21
C1601 a_4379_3311# a_4268_2767# 2.99e-20
C1602 a_5943_2767# a_3891_3432# 9.65e-19
C1603 a_1697_743# a_2367_1135# 0.011478f
C1604 a_2235_1256# a_3148_1135# 1.9e-19
C1605 a_6047_2045# a_5545_2925# 5.39e-21
C1606 a_849_3017# a_1125_2767# 3.44e-19
C1607 a_2325_5713# a_1823_6575# 0.005887f
C1608 a_4493_957# a_3663_1135# 2.73e-20
C1609 a0 a_5192_4943# 7.49e-20
C1610 DVDD a_3072_3311# 0.686255f
C1611 a_6828_1679# a_5779_4943# 6.11e-20
C1612 a_4751_1831# a_4528_1501# 1.71e-19
C1613 b3 a_395_854# 4.35e-22
C1614 a_1697_743# a_4103_1501# 0.028066f
C1615 a_4493_591# a_443_591# 6.25e-20
C1616 a1 a_3297_6031# 2.22e-19
C1617 DVDD a_2263_4943# 8.16e-19
C1618 b2 a_1775_4118# 0.033149f
C1619 b5 a_527_4943# 4.6e-19
C1620 a_5009_6183# a_5653_5095# 0.004237f
C1621 P1 a_1236_4943# 0.005587f
C1622 a_757_6281# a_3072_4399# 2.12e-20
C1623 a_3387_6031# a_5821_5101# 1.69e-20
C1624 b1 a_1457_3133# 2.8e-22
C1625 a_5135_6031# a_4399_4943# 8.24e-19
C1626 a_219_1929# a_301_1929# 0.006406f
C1627 a_259_1831# a_469_1929# 0.074207f
C1628 a_5045_6397# a_2235_5608# 1.49e-20
C1629 a_3983_5608# a_2283_5487# 0.084312f
C1630 a_4535_854# a_5289_1433# 9.21e-20
C1631 a2 a_4839_5309# 0.001175f
C1632 a_5503_2767# a_4544_3855# 0.747947f
C1633 DVDD a_4379_3311# 0.265493f
C1634 a_3164_2223# a_4287_3855# 2.14e-20
C1635 a_3571_2767# a_3931_3855# 8.21e-20
C1636 a_1775_854# a_4793_1679# 6.25e-19
C1637 a_3747_6575# a_2157_5719# 3.79e-19
C1638 DVDD a_5575_6031# 0.046163f
C1639 a_317_743# a_2367_1501# 0.001259f
C1640 a_3813_3543# a_4636_3311# 0.175135f
C1641 a_485_749# a_1733_957# 0.006823f
C1642 a_527_957# a_883_957# 0.009846f
C1643 a2 a_3148_5487# 8.4e-20
C1644 a_1697_743# a_4456_1135# 0.004869f
C1645 a_1308_2589# a_395_2344# 6.11e-20
C1646 a_6644_4943# a_5821_5101# 3.62e-19
C1647 b5 a_3891_3432# 0.24493f
C1648 a_4456_6575# a_627_5487# 4.95e-20
C1649 a_4751_1831# a_6173_1455# 0.002106f
C1650 a_4528_6575# a_3537_6807# 1.3e-19
C1651 a_6572_4943# a_5779_4943# 3.73e-20
C1652 a_2327_4520# a_4351_5206# 3.72e-20
C1653 a_1692_4399# a_317_5095# 1.75e-19
C1654 DVDD a_1784_1679# 1.30899f
C1655 a_2815_3677# a_3168_3677# 2.18e-19
C1656 a_1895_6397# a_481_6281# 0.0072f
C1657 a_481_6281# b2 0.00712f
C1658 a_4943_1653# a_1823_4943# 0.002359f
C1659 a_3983_4520# a_4728_4399# 0.185497f
C1660 a_4073_4625# a_3799_4118# 0.297665f
C1661 a_2377_2223# a_1775_4118# 4.66e-20
C1662 a_2045_2223# a_1775_854# 4.47e-19
C1663 a_501_5719# a_1492_5487# 1.05e-19
C1664 P7 a_395_854# 1.95e-20
C1665 a_5135_6031# a_3261_6183# 1.81e-19
C1666 b2 a_3517_5807# 4.38e-20
C1667 a_2980_5487# a_4103_6575# 1.61e-19
C1668 a_763_1256# a_883_2589# 1.4e-21
C1669 a2 a_5075_1148# 1.37e-19
C1670 a_219_1929# a_685_1367# 0.008572f
C1671 a_4252_2045# a_2467_2223# 2.2e-19
C1672 a_2327_3432# a_2243_1929# 3.18e-19
C1673 P3 a_3517_5487# 0.082531f
C1674 b5 a_4860_1367# 2.48e-20
C1675 a1 a_627_5487# 0.031566f
C1676 a_1329_6183# a_2283_5487# 1.46e-19
C1677 a_947_4520# a_2375_4399# 5.83e-19
C1678 a_501_5719# a_1492_5853# 4.08e-19
C1679 a_4667_591# a_1865_749# 0.059152f
C1680 a_4268_2767# a_4287_4221# 2.26e-21
C1681 b2 a_1861_5807# 5.57e-19
C1682 a_2551_2589# a_2244_2767# 0.005153f
C1683 a_3571_2767# a_4252_1679# 8.27e-20
C1684 a0 a_1308_5309# 1.43e-19
C1685 a_2688_5309# a_2263_5309# 1.31e-19
C1686 a_4268_2767# a_3891_3432# 0.002721f
C1687 a_5188_2223# a_5227_3855# 0.001315f
C1688 a_2045_2223# a_573_4105# 0.001439f
C1689 a_5923_2223# a_3847_3855# 1.91e-19
C1690 a_6173_2543# a_3891_3432# 1.67e-19
C1691 P1 a_883_5309# 0.02283f
C1692 a_2249_4631# a_6412_4007# 8.4e-21
C1693 a_3983_4520# a_3072_3311# 0.016506f
C1694 a_3609_4399# a_3847_3855# 1.31e-20
C1695 a_1037_4625# a_573_4105# 8.24e-21
C1696 a_2375_4399# a_5227_3855# 0.215978f
C1697 a_947_4520# a_849_4105# 0.037457f
C1698 a_3799_4118# a_1865_4013# 0.012043f
C1699 a2 a_1508_1135# 3.07e-21
C1700 DVDD a_527_4943# 0.034642f
C1701 a_1455_6031# a1 0.067241f
C1702 DVDD a_1895_6031# 8.16e-19
C1703 a_2688_4943# a_2375_4399# 2.58e-19
C1704 a_3241_4943# a_2249_4631# 1.06e-19
C1705 a_4931_2589# a_4533_2449# 0.047425f
C1706 a_2327_3432# a_1823_4943# 2.38e-19
C1707 DVDD P4 0.192665f
C1708 b1 P2 0.019275f
C1709 a_1435_4765# a_849_3017# 5.02e-22
C1710 a_2520_3855# a_485_749# 2.34e-19
C1711 DVDD a_4287_4221# 0.155939f
C1712 a_2045_2223# a_1039_1942# 9.4e-20
C1713 a_5095_1929# a_2244_2767# 2.5e-19
C1714 a_4268_2767# a_4860_1367# 3.81e-20
C1715 a_3983_4520# a_4379_3311# 1.75e-20
C1716 a_2249_4631# a_1421_2919# 8.09e-22
C1717 b4 a_4824_4765# 3.36e-19
C1718 DVDD a_3891_3432# 1.73174f
C1719 a4 a_4073_4625# 3.51e-19
C1720 a_1865_4013# a_1823_3855# 0.215144f
C1721 a_1865_4013# a_1865_749# 3.74e-20
C1722 a_1769_3631# a_995_4399# 8.73e-20
C1723 a_3537_1367# a_3164_2223# 1.55e-19
C1724 a_2285_3677# a_1037_4625# 1.62e-19
C1725 a_3827_2045# a_3571_2767# 0.006159f
C1726 a_1125_3017# a_2520_3855# 0.1714f
C1727 a_2375_4399# a_6000_6031# 1.36e-20
C1728 DVDD a_975_3311# 0.236996f
C1729 a_995_4399# a_2235_5608# 1.47e-20
C1730 a_1455_6031# a_4115_4765# 1.66e-20
C1731 a_4533_2449# a_5545_2925# 6.44e-19
C1732 a_961_1831# a_1527_1679# 0.049291f
C1733 a_2263_5309# a_2616_5309# 2.18e-19
C1734 b5 a_2520_3855# 0.013343f
C1735 a5 a_395_854# 1.05e-20
C1736 DVDD a_1733_957# 5e-19
C1737 a_5135_6031# a_5689_4943# 3.11e-21
C1738 a2 a_1492_5487# 9.74e-21
C1739 a_1907_6575# b0 0.004496f
C1740 a_3240_3311# a_3072_3311# 0.007578f
C1741 DVDD a_4860_1367# 0.089217f
C1742 a4 a_1865_4013# 0.070062f
C1743 b3 a_2520_6575# 1.78e-20
C1744 a_1784_1679# a_1880_1679# 0.005625f
C1745 a0 a_3537_6807# 9.31e-19
C1746 a_317_743# a_895_1135# 0.002017f
C1747 b3 a_1823_6575# 2.21e-19
C1748 DVDD a_353_5309# 7.13e-19
C1749 a_501_5719# b0 0.035547f
C1750 b4 a_4483_5309# 0.007471f
C1751 a_3655_2767# a_4011_2767# 0.008475f
C1752 a_6219_4943# a_6644_4943# 8.12e-20
C1753 b4 b3 0.059514f
C1754 b2 P1 0.002015f
C1755 DVDD a_3827_1679# 8.2e-19
C1756 DVDD P10 0.195214f
C1757 a1 b5 0.431401f
C1758 a_2459_4399# a_1775_4118# 8.5e-19
C1759 b2 a_3523_3030# 0.055432f
C1760 a_4535_854# a_317_743# 7.09e-19
C1761 a_2980_5487# a_2327_4520# 3.94e-19
C1762 a_1497_6189# a0 0.387366f
C1763 a_5023_591# DVDD 8.16e-19
C1764 a_2341_2455# a_4877_1679# 2.37e-19
C1765 a_763_1256# a_883_591# 7.93e-20
C1766 b4 a_1328_3311# 1.03e-19
C1767 a_4401_2589# a_1775_854# 0.006958f
C1768 a_2377_2223# a_317_743# 3.07e-21
C1769 a_4457_743# a_395_854# 4.56e-19
C1770 a_4625_749# a_6403_1679# 0.065211f
C1771 b1 a_4073_4625# 0.003676f
C1772 a_6005_2223# a_5503_2767# 0.007951f
C1773 a_4575_2589# a_995_4399# 8.03e-21
C1774 a_5923_2223# a_4544_3855# 0.005004f
C1775 a_1435_4399# a_443_4943# 1.33e-20
C1776 a_5135_6031# a_4351_5206# 3.05e-21
C1777 a_4073_4625# a_3931_4221# 0.001207f
C1778 a_3799_4118# a_3757_4221# 2.38e-20
C1779 a_3609_4399# a_4544_3855# 1.52e-19
C1780 a_2375_4399# a_4640_4221# 9.65e-21
C1781 a_3983_4520# a_4287_4221# 0.001842f
C1782 P8 a_4625_749# 0.011929f
C1783 a_3261_6183# a_1775_6696# 0.013796f
C1784 DVDD a_3297_2045# 4.94e-19
C1785 a_3983_4520# a_3891_3432# 8.86e-19
C1786 a_883_2223# a_485_749# 2.36e-21
C1787 DVDD a_2520_3855# 0.735995f
C1788 a_4456_6575# DVDD 5.06e-19
C1789 a_1823_6575# a_527_5309# 8.83e-20
C1790 a_2467_2223# a_2341_2455# 0.809189f
C1791 a_4636_3311# a_1692_4399# 3.94e-19
C1792 a_995_4399# a_2341_2455# 7.53e-21
C1793 b1 a_1865_4013# 0.138259f
C1794 a_2412_2767# a_849_4105# 3.43e-20
C1795 a_4252_2045# a_2341_2455# 3.99e-20
C1796 a_2907_2223# a_2375_3311# 4.33e-21
C1797 a_4483_4943# a_3813_3543# 3.36e-21
C1798 a_685_1367# a_883_957# 1.32e-19
C1799 a_2249_3543# a_3072_3311# 0.156745f
C1800 a1 a_6644_5309# 9.44e-21
C1801 a_553_1679# a_2467_2223# 0.002306f
C1802 a_1171_2045# a_1527_2045# 0.009846f
C1803 a_4847_1653# a_4709_1929# 0.416227f
C1804 a_1697_743# a_2493_1679# 0.001044f
C1805 b4 a_4896_4399# 1.78e-19
C1806 a_1775_854# a_5289_1433# 0.002061f
C1807 a_1435_4765# a_1329_6183# 2.62e-20
C1808 a_2467_2223# a_2980_1135# 0.001183f
C1809 a_2551_2589# a_1125_3017# 0.03422f
C1810 a_3332_2589# a_3164_2223# 0.00792f
C1811 a_3241_3855# a_1865_4013# 5.18e-19
C1812 a_2688_3855# a_1823_3855# 8.59e-21
C1813 b3 a_3571_2767# 3.97e-20
C1814 a_763_1256# a_1604_1501# 7.33e-20
C1815 a0 a3 0.147281f
C1816 b0 a2 0.322902f
C1817 DVDD a1 1.43059f
C1818 a_757_6281# a_1907_3855# 1.21e-19
C1819 a0 a_6412_5719# 1.1e-19
C1820 a_2980_5487# a_4115_4399# 3.64e-21
C1821 a_4483_5309# a_4031_5487# 3.27e-19
C1822 a_5192_5309# a_2283_5487# 2.24e-19
C1823 a_4839_5309# a_3905_5719# 1.53e-19
C1824 b5 a_2417_4625# 1.83e-19
C1825 b3 a_4031_5487# 0.044105f
C1826 a_5356_2223# a_4268_2767# 6.73e-20
C1827 a5 a_5667_3855# 8.36e-19
C1828 a2 a_3813_3543# 0.10951f
C1829 a_1697_743# a_1865_749# 0.503535f
C1830 a_2157_5719# a_3573_6941# 1.73e-19
C1831 a_3983_5608# a_3827_6031# 9.79e-19
C1832 a_4728_4399# a_5653_5095# 0.039956f
C1833 b1 a_5045_6031# 1.61e-19
C1834 a_4751_1831# a_3847_3855# 0.004784f
C1835 a_4073_4625# a_5779_4943# 9.39e-20
C1836 a_1697_743# a_1823_3855# 0.009836f
C1837 a_2325_5713# a_2375_4399# 0.004353f
C1838 a_1775_854# a_1775_4118# 0.197671f
C1839 a_995_4399# a_317_5095# 0.025765f
C1840 a_3747_6575# a_3517_5487# 0.003673f
C1841 a3 a_2723_5487# 0.001744f
C1842 a_5265_5807# a_2283_5487# 2.82e-21
C1843 a5 a_4804_3677# 1.83e-19
C1844 a_1733_591# a_443_591# 1.33e-19
C1845 a_4625_749# a_5503_2767# 0.001484f
C1846 a_317_2455# a_409_3543# 0.003374f
C1847 a_1788_4399# a_1435_4399# 2.18e-19
C1848 a_5448_591# a_4535_854# 6.11e-20
C1849 DVDD a_4115_4765# 0.001389f
C1850 a_1329_6183# a_2367_5853# 9.98e-19
C1851 a_248_4631# a_409_3543# 0.001114f
C1852 a_4493_957# a_1865_749# 0.006823f
C1853 a_2243_1929# a_1421_2919# 4.64e-21
C1854 a_573_4105# a_1775_4118# 0.016604f
C1855 DVDD a_5356_2223# 4.72e-19
C1856 a4 a_1697_743# 0.02374f
C1857 a_6412_4007# a_1823_4943# 0.989394f
C1858 a_3847_3855# a_4399_4943# 6.32e-22
C1859 a_1865_4013# a_5779_4943# 3.15e-21
C1860 a_1037_4625# a_1435_4765# 0.045338f
C1861 a_995_4399# a_1079_4765# 0.059224f
C1862 b3 a_3655_3133# 5.84e-20
C1863 a_4457_743# a_5837_1831# 0.015691f
C1864 a5 a_1823_6575# 0.001856f
C1865 a_757_6281# a_627_5487# 0.019651f
C1866 a_5081_2767# a_3571_2767# 1.49e-20
C1867 a_2375_4399# a_2688_4221# 9.24e-20
C1868 a5 b4 0.354474f
C1869 a_1039_1942# a_1775_4118# 0.017181f
C1870 a_1497_6189# a_1067_5853# 3.19e-20
C1871 a_1539_6397# a_501_5719# 1.25e-19
C1872 a4 a_5821_5101# 0.050505f
C1873 b0 a_5575_6397# 0.004285f
C1874 a_1421_2919# a_1823_4943# 2.06e-20
C1875 a_2327_3432# a_1987_3133# 7.36e-20
C1876 a_2285_3677# a_1775_4118# 5.29e-19
C1877 a_553_1679# a_2325_1929# 0.005489f
C1878 a_1697_743# a_1527_2045# 8.84e-21
C1879 a_1775_4118# a_2283_5487# 5.85e-20
C1880 DVDD a_883_2223# 0.156119f
C1881 a_1823_4943# a_443_4943# 0.003516f
C1882 a_5653_5095# a_5575_6031# 2.24e-20
C1883 a_4456_1501# a_3663_1135# 3e-19
C1884 a_2980_5487# a_5135_6031# 3.62e-20
C1885 a_1455_6031# a_757_6281# 5.94e-19
C1886 a_3387_6031# a_5009_6183# 0.829751f
C1887 b1 a_1365_6031# 2.08e-19
C1888 DVDD a_2417_4625# 0.588404f
C1889 a5 a_1251_1135# 2.09e-19
C1890 a_5095_1929# a_4268_2767# 0.001456f
C1891 DVDD a_2551_2589# 0.001386f
C1892 a_2367_1135# a_2723_1135# 0.009846f
C1893 a_1823_3855# a_1907_4221# 0.030161f
C1894 b1 a_3757_4221# 2.05e-20
C1895 a_1865_4013# a_2263_4221# 0.080896f
C1896 a0 a_4824_5487# 2.26e-19
C1897 a_2244_2767# a_1987_2767# 0.024253f
C1898 a1 a_3983_4520# 0.172018f
C1899 b2 a_4535_854# 0.021106f
C1900 a_4575_2589# a_2341_2455# 0.004551f
C1901 a_1907_591# a_1865_749# 0.033252f
C1902 a_2263_591# a_485_749# 0.036223f
C1903 DVDD a_2367_5487# 0.162119f
C1904 a_3891_3432# a_2249_3543# 5.82e-19
C1905 a_4103_1501# a_4456_1501# 2.18e-19
C1906 a_4268_2767# a_4667_957# 1.07e-20
C1907 a_501_5719# a_1692_4399# 1.05e-21
C1908 b2 a_1788_4765# 1.72e-19
C1909 a_3813_3543# a_4732_3677# 5.43e-19
C1910 a_395_2344# a_619_3311# 0.033003f
C1911 a_4636_3311# a_4023_3677# 3.15e-19
C1912 a_481_6281# a_2283_5487# 0.001388f
C1913 a_3523_3030# a_4379_3677# 0.036284f
C1914 a_4103_6575# P3 0.02283f
C1915 a_4528_1135# a_3663_1135# 1.13e-19
C1916 a_297_3017# a_975_3311# 0.017703f
C1917 a_4436_2767# a_4268_2767# 0.008644f
C1918 DVDD a_5095_1929# 0.262058f
C1919 b0 a_2263_6941# 0.002036f
C1920 a_4751_1831# a_4544_3855# 1.85e-20
C1921 a_1775_6696# a_1907_5309# 1.77e-20
C1922 a_469_1929# a_685_1367# 0.001202f
C1923 a_1037_4625# a_1079_4399# 0.089278f
C1924 a_2375_4399# a_4824_4765# 1.2e-19
C1925 a_2249_4631# a_4896_4765# 3.7e-19
C1926 a_3609_4399# a_4471_4765# 0.044609f
C1927 a_3517_5807# a_2283_5487# 1.37e-19
C1928 a_3983_4520# a_4115_4765# 0.021551f
C1929 P7 a_5448_957# 0.007578f
C1930 a_6173_2223# a_5188_2223# 0.0085f
C1931 a_6005_2223# a_5923_2223# 0.006406f
C1932 a1 a_1308_4943# 2.27e-19
C1933 a5 a_3571_2767# 2.74e-19
C1934 DVDD a_4667_957# 0.162877f
C1935 a_5863_4943# a_4728_4399# 1.51e-19
C1936 a_757_6281# a_1125_3017# 3.38e-20
C1937 b1 a_5821_5101# 1.01e-19
C1938 a_553_1679# a_2341_2455# 0.001041f
C1939 a_3571_2767# a_3747_1135# 0.02501f
C1940 a5 a_2815_3677# 0.003303f
C1941 a_1775_854# a_317_743# 0.03768f
C1942 a_2341_2455# a_2980_1135# 2.71e-19
C1943 a5 a_4031_5487# 0.002818f
C1944 a_757_6281# b5 8.65e-19
C1945 a_1692_4399# a_1860_4765# 0.008011f
C1946 a_4457_743# a_5413_2767# 9.03e-20
C1947 DVDD a_4471_4399# 0.155261f
C1948 a_4712_4221# a_1823_4943# 8.44e-20
C1949 b4 a_2375_3311# 0.074877f
C1950 a_3517_5487# a_4896_5853# 1.41e-21
C1951 a_997_1679# a_317_743# 1.19e-20
C1952 a_3891_3432# a_5653_5095# 0.011722f
C1953 a_4847_1653# a_4860_1367# 0.007162f
C1954 a_4751_1831# a_443_591# 0.080816f
C1955 a_4401_2223# a_3847_3855# 6.17e-20
C1956 a_3537_1367# a_4103_1135# 0.013222f
C1957 a_297_4105# a_395_854# 0.006427f
C1958 a_5289_1433# a_5923_1135# 0.013675f
C1959 a0 a_3609_4399# 0.001732f
C1960 a_3983_4520# a_2417_4625# 0.001344f
C1961 a_685_1367# a_1236_2589# 0.005587f
C1962 a_4073_4625# a_2327_4520# 7.17e-20
C1963 a_1697_743# a_5779_4943# 2.24e-19
C1964 a_763_1256# a_1421_2919# 0.001164f
C1965 a_975_3677# a_317_2455# 4.66e-21
C1966 a_3523_3030# a_1775_854# 0.005271f
C1967 a_1421_2919# a_2459_4765# 4.41e-21
C1968 b3 a_2375_4399# 0.530034f
C1969 a_3241_6895# a_1775_6696# 1.34e-19
C1970 a_1697_743# a_3471_1679# 0.004835f
C1971 a_4457_743# a_3571_2767# 9.27e-19
C1972 a2 a_1692_4399# 0.057888f
C1973 a_4943_1653# a_5503_2767# 0.054253f
C1974 a_4931_2223# a4 0.001051f
C1975 a_1039_1942# a_317_743# 0.003883f
C1976 b1 a_1907_4221# 0.004612f
C1977 a_6219_4943# a4 4.23e-19
C1978 a_4457_743# a_4031_5487# 4.58e-20
C1979 b3 a_849_4105# 0.085914f
C1980 a_2249_3543# a_2520_3855# 0.105587f
C1981 a_4625_749# a_5923_2223# 6.09e-20
C1982 DVDD a_2263_591# 8.35e-19
C1983 a_1865_4013# a_2327_4520# 0.011797f
C1984 a_5821_5101# a_5779_4943# 0.265695f
C1985 a_2616_3855# a_2520_3855# 0.005656f
C1986 a5 a_5356_2589# 1.54e-20
C1987 a_2980_5487# a_1775_6696# 0.008478f
C1988 a_2235_1256# a_3827_2045# 0.003858f
C1989 a_1697_743# a_2493_1929# 0.004611f
C1990 a_2243_1929# a_3537_1367# 2.8e-20
C1991 a_757_6281# DVDD 0.725964f
C1992 a_2375_3311# a_3571_2767# 0.269463f
C1993 a_3813_3543# a_3164_2223# 0.015796f
C1994 b0 a_3905_5719# 2.11e-19
C1995 a_5345_1929# a_2244_2767# 7.98e-20
C1996 DVDD a_3148_1135# 6.8e-19
C1997 a_2375_3311# a_2815_3677# 0.038227f
C1998 a_2045_2543# a4 1.08e-20
C1999 a3 a_2327_3432# 1.95e-19
C2000 a1 a_297_3017# 4.16e-21
C2001 a_3523_3030# a_2283_5487# 4.03e-21
C2002 a1 a_2249_3543# 2.24e-20
C2003 a0 a_4621_6031# 6.8e-20
C2004 a_4535_854# a_5376_957# 1.6e-19
C2005 a5 a_2459_3311# 0.001143f
C2006 a_3983_4520# a_4471_4399# 0.008926f
C2007 a_2249_4631# a_1508_1135# 6.81e-20
C2008 a_3517_5487# a_3573_6941# 8.92e-19
C2009 a_4073_4625# a_4115_4399# 0.089711f
C2010 a_3799_4118# a_3941_4399# 0.006857f
C2011 a_4011_2767# a_3799_4118# 1.67e-21
C2012 a_2263_6575# a_1329_6183# 4.32e-19
C2013 a_5837_1831# a_6047_2045# 0.011205f
C2014 a_1125_3017# a_1987_2767# 1.36e-20
C2015 a_4457_743# a_5448_957# 2.39e-20
C2016 a_4103_6941# a_3537_6807# 0.046469f
C2017 a_3747_6941# a_627_5487# 0.017809f
C2018 a_5587_3133# a_4535_854# 0.040116f
C2019 a_2325_5713# a_2688_6575# 4.71e-20
C2020 a_5943_3133# a_1692_4399# 2.66e-20
C2021 a4 a_895_1501# 7.99e-20
C2022 a_395_2344# a_1171_2045# 2.37e-19
C2023 a_4839_4943# a_3983_5608# 6.11e-20
C2024 a_4457_743# a_5356_2589# 9.15e-20
C2025 a_2815_4399# a_1692_4399# 0.006006f
C2026 a_1421_2919# a_1987_3133# 0.011819f
C2027 a_3655_2767# a_3072_3311# 2.61e-21
C2028 a_6368_3133# a_5227_3855# 2.96e-19
C2029 a_5311_3855# a_1692_4399# 0.04028f
C2030 a4 a_297_2767# 2.7e-19
C2031 a_481_6281# a_1435_4765# 8.47e-21
C2032 a_2263_957# a_2616_957# 2.18e-19
C2033 a_2375_3311# a_3655_3133# 0.120927f
C2034 DVDD a_5002_1174# 1.94e-19
C2035 a_1455_6031# a_3747_6941# 1.55e-20
C2036 a1 a_5653_5095# 0.045192f
C2037 a_685_1367# a_1308_591# 6.67e-20
C2038 b0 a_5863_5309# 4.97e-20
C2039 a_1421_2919# a_1733_3855# 4.61e-21
C2040 a_219_1929# a_553_1679# 0.167135f
C2041 a_6005_2223# a_4751_1831# 2.68e-19
C2042 a_5284_2223# a_1697_743# 6.92e-20
C2043 a_4011_2767# a4 0.0038f
C2044 a2 a_5311_4221# 1.62e-19
C2045 a_1907_4221# a_2263_4221# 0.009846f
C2046 a_527_2223# a_395_2344# 0.032668f
C2047 a_883_2223# a_297_3017# 7.01e-21
C2048 a_947_4520# a_627_5487# 4.05e-19
C2049 a2 a_2285_4399# 3.56e-21
C2050 b3 a_3827_6397# 1.83e-19
C2051 a_4709_1929# a_3663_1135# 0.05138f
C2052 a5 a_5188_2223# 3.24e-19
C2053 a_3747_6575# a_4103_6575# 0.009846f
C2054 b2 a_1775_854# 1.46e-20
C2055 a_3261_6183# a_4528_6575# 3.7e-19
C2056 a2 a_4712_3855# 4.03e-20
C2057 a_2249_3543# a_2417_4625# 5.74e-20
C2058 a_2551_2589# a_2249_3543# 6.32e-21
C2059 b3 a_1125_3855# 9.34e-20
C2060 a_1508_1135# a_1435_4399# 3.11e-19
C2061 P11 a_2467_2223# 8.57e-19
C2062 a_501_5719# a_995_4399# 3.53e-20
C2063 a5 a_2375_4399# 0.004644f
C2064 a_3387_6031# a_4728_4399# 3.67e-19
C2065 a_2325_5713# a_2815_4765# 3e-19
C2066 a_2263_4943# a_2157_5719# 7.04e-20
C2067 a5 a_1171_1679# 7.59e-19
C2068 b1 a_4896_5853# 2.23e-19
C2069 a_1775_854# a_895_1135# 3.15e-19
C2070 a_4636_3311# a_2341_2455# 0.115457f
C2071 a_1455_6031# a_947_4520# 9.51e-20
C2072 a_2375_3311# a_2459_3311# 0.030161f
C2073 a_6219_4943# a_5779_4943# 0.042312f
C2074 a_6412_4007# a_6403_1679# 0.023794f
C2075 a_4544_3855# a_4351_5206# 8.22e-20
C2076 b4 a_297_4105# 7.39e-20
C2077 b2 a_573_4105# 0.006029f
C2078 a5 a_849_4105# 0.095397f
C2079 a_2377_2589# a_1697_743# 4.45e-21
C2080 DVDD a_1987_2767# 0.003565f
C2081 a_5023_957# a_5448_957# 1.31e-19
C2082 DVDD a_1251_1501# 0.0465f
C2083 a_4535_854# a_1775_854# 0.052171f
C2084 a_4103_6941# a3 7.97e-20
C2085 a_2412_2767# a_2244_2767# 0.008521f
C2086 b4 a_849_3017# 0.234456f
C2087 a_1865_4013# a_4528_1501# 2.46e-19
C2088 b2 a_1039_1942# 0.001168f
C2089 a_4943_1653# a_5923_2223# 0.192567f
C2090 a_2907_2223# a_2045_2223# 0.009858f
C2091 a_2551_2223# a_2467_2223# 0.030161f
C2092 a_4457_743# a_5188_2223# 0.246505f
C2093 a0 a_4399_4943# 0.102279f
C2094 a_4309_5309# a_4399_4943# 0.006823f
C2095 a_4483_5309# a_3072_4399# 0.011205f
C2096 a_4457_743# a_2375_4399# 5.9e-22
C2097 a_2045_2223# a_395_854# 4.95e-20
C2098 a_355_1653# a_485_749# 6.5e-19
C2099 b2 a_2285_3677# 1.82e-19
C2100 a_5943_2767# a_5227_3855# 0.005557f
C2101 a_501_5719# a_2235_5608# 0.001059f
C2102 b3 a_3072_4399# 0.096316f
C2103 a5 a_2815_3311# 9.13e-19
C2104 b2 a_2283_5487# 0.214718f
C2105 a_409_3543# a_527_4943# 4.97e-21
C2106 a_4483_4943# a_995_4399# 4.63e-21
C2107 a_4847_1653# a_5095_1929# 0.246839f
C2108 a_4751_1831# a_4625_749# 0.02571f
C2109 a_248_4631# a_1823_3855# 1.22e-19
C2110 a_5135_6031# a_5045_6031# 0.006958f
C2111 a_5009_6183# a_5219_6031# 0.04028f
C2112 a_2980_1135# a_2723_1501# 0.023012f
C2113 a_3387_6031# a_5575_6031# 0.005587f
C2114 a_1497_6189# a_443_4943# 0.001147f
C2115 a_355_1653# a_1125_3017# 0.001101f
C2116 a_4533_2449# a_5837_1831# 0.002047f
C2117 a_1784_1679# a_3663_1135# 0.003476f
C2118 a_947_4520# a_1125_3017# 1.2e-21
C2119 a_4847_1653# a_4667_957# 2.34e-20
C2120 a4 a_317_2455# 0.00285f
C2121 b5 a_355_1653# 9.37e-19
C2122 P11 a_2325_1929# 2.25e-19
C2123 a2 a_995_4399# 3.61e-19
C2124 b0 a_2249_4631# 0.393447f
C2125 a4 a_248_4631# 0.004362f
C2126 b5 a_947_4520# 0.014049f
C2127 a_1865_4013# a_6173_1455# 7.04e-21
C2128 a_1775_4118# a_3076_1501# 3.73e-20
C2129 a_3164_2223# a_1692_4399# 4.6e-20
C2130 a_1508_1135# a_3148_1501# 1.99e-20
C2131 a_1784_1679# a_2367_1135# 0.011205f
C2132 a_3813_3543# a_2249_4631# 1.48e-21
C2133 a_2375_3311# a_2375_4399# 0.001601f
C2134 a_4625_749# a_6756_2045# 4.35e-21
C2135 a_975_3311# a_409_3543# 0.011819f
C2136 a_5503_2767# a_6412_4007# 0.018107f
C2137 a_3983_5608# a_2520_6575# 2.91e-20
C2138 a_5075_1148# a_1823_4943# 2.52e-19
C2139 b4 a_849_2767# 2.52e-19
C2140 a_6412_4007# a_6412_5719# 1.99e-19
C2141 b5 a_5227_3855# 0.175829f
C2142 a_3261_6183# a0 0.001372f
C2143 a_2244_2767# a_4252_1679# 1.49e-19
C2144 a_3977_4943# a_3905_5719# 0.009374f
C2145 a_2375_3311# a_849_4105# 0.288873f
C2146 a3 a_3241_4943# 3.85e-19
C2147 a_2325_5713# a_3297_6031# 7.29e-20
C2148 a_3747_6941# DVDD 0.034685f
C2149 b4 a_3983_5608# 0.321326f
C2150 a_4896_4399# a_3072_4399# 7.9e-21
C2151 a_1508_1135# a_1823_4943# 0.009313f
C2152 a_4471_4399# a_5653_5095# 5.83e-21
C2153 b2 a_4931_2589# 5.07e-20
C2154 a_961_1831# a_1457_3133# 6.59e-20
C2155 a_259_1831# a_763_1256# 0.246688f
C2156 a3 a_1421_2919# 0.025076f
C2157 a_5345_1929# a_4268_2767# 1.46e-19
C2158 a_3387_6031# a_1895_6031# 3.49e-20
C2159 b4 a_5137_4221# 1.77e-20
C2160 b4 a_4533_2449# 7.61e-19
C2161 a_5009_6183# b1 0.002876f
C2162 a3 a_443_4943# 1.93e-19
C2163 a2 a_2235_5608# 1.53917f
C2164 a_4931_2223# a_5284_2223# 2.18e-19
C2165 b4 a_4640_3855# 6.23e-19
C2166 a_3387_6031# P4 1.74e-19
C2167 a5 a_1125_3855# 1.49e-19
C2168 a_757_6281# a_297_3017# 7.32e-19
C2169 a_2375_3311# a_2815_3311# 0.006402f
C2170 a_3827_2045# a_2244_2767# 0.011819f
C2171 a_2327_3432# a_3168_3311# 3.03e-19
C2172 a_4364_3133# a_3847_3855# 1.59e-19
C2173 a_4268_2767# a_5227_3855# 2.52e-20
C2174 b2 a_5545_2925# 0.001108f
C2175 P11 a_2341_2455# 3.05e-20
C2176 a_1329_6183# a_2520_6575# 0.002258f
C2177 DVDD a_5345_1929# 0.302871f
C2178 b1 a_317_2455# 2.47e-19
C2179 DVDD a_355_1653# 0.870592f
C2180 a_4931_2589# a_4535_854# 0.008432f
C2181 DVDD a_947_4520# 0.890367f
C2182 b1 a_248_4631# 0.006525f
C2183 a_1823_6575# a_1329_6183# 0.05956f
C2184 a_2325_5713# a_2688_6941# 2.08e-20
C2185 a_4533_2449# a_5413_2767# 5.23e-19
C2186 a_6296_2767# a_4544_3855# 5.43e-19
C2187 a_4860_1367# a_3663_1135# 0.016669f
C2188 P11 a_553_1679# 0.002055f
C2189 a_1697_743# a_3076_1135# 8.3e-20
C2190 a_6368_2767# a_3891_3432# 8.08e-21
C2191 b3 a_2815_4765# 0.037205f
C2192 a_6412_4007# a_6572_5309# 1.62e-20
C2193 a4 a_1457_2767# 1.84e-19
C2194 a_2325_5713# a_627_5487# 1.46e-19
C2195 a0 a_5689_4943# 3.54e-19
C2196 a_4535_854# a_5545_2925# 0.095005f
C2197 a_4751_1831# a_5223_1501# 2.11e-19
C2198 DVDD a_5227_3855# 0.834871f
C2199 a_1697_743# a_4528_1501# 0.008448f
C2200 a_3827_1679# a_3663_1135# 3.29e-19
C2201 a_4471_4765# a_4351_5206# 6.22e-19
C2202 P10 a_3663_1135# 0.003019f
C2203 a5 a_3072_4399# 9.55e-19
C2204 P3 a_1775_6696# 0.04309f
C2205 a_5009_6183# a_5779_4943# 0.071658f
C2206 a_501_5719# a_317_5095# 6.91e-20
C2207 a_5135_6031# a_5821_5101# 0.001459f
C2208 a_5023_591# a_3663_1135# 0.001117f
C2209 a_1455_6031# a_2325_5713# 0.047458f
C2210 a_2551_2223# a_2341_2455# 0.011205f
C2211 P6 a_1823_4943# 0.010516f
C2212 a2 a_5264_5309# 2.01e-19
C2213 a_3983_5608# a_4031_5487# 0.198933f
C2214 a_4533_2449# a_3571_2767# 3.62e-19
C2215 DVDD a_4804_3311# 8.41e-19
C2216 a1 a_6277_4719# 1.1e-19
C2217 a1 a_409_3543# 0.002857f
C2218 a_2157_5719# a_2520_3855# 2.1e-21
C2219 a_619_3677# b3 0.003229f
C2220 a_4533_2449# a_4031_5487# 5.92e-21
C2221 a_1775_854# a_5345_1679# 3.98e-19
C2222 b2 a_1435_4765# 0.004656f
C2223 DVDD a_6000_6031# 9.45e-20
C2224 a_501_5719# a_1079_4765# 2.01e-22
C2225 a_2263_6575# a_481_6281# 6.73e-19
C2226 a_4943_1653# a_4751_1831# 4.89e-19
C2227 b4 a_2045_2223# 6.78e-20
C2228 b5 a_3931_3855# 0.002402f
C2229 a_4751_1831# a_5319_1174# 4.18e-19
C2230 b4 a_1037_4625# 3.3e-21
C2231 a_984_6183# a_627_5487# 0.303718f
C2232 a2 a_2341_2455# 0.084367f
C2233 a_2520_3855# a_3663_1135# 0.008589f
C2234 a_3164_2223# a_4023_3677# 2.43e-20
C2235 a_763_1256# a_1508_1135# 0.106484f
C2236 a0 a_4351_5206# 0.113644f
C2237 a_1775_4118# a_2285_4765# 7.25e-20
C2238 a_4309_5309# a_4351_5206# 4.48e-20
C2239 DVDD a_1952_2045# 6.36e-19
C2240 a_2327_3432# a_2263_3855# 2.24e-19
C2241 a_961_1831# a_619_3311# 2.9e-19
C2242 a_4379_3677# a_2283_5487# 3.89e-21
C2243 a_2907_2223# a_1775_4118# 1.27e-20
C2244 a_355_1653# a_353_2589# 0.006958f
C2245 a_317_2455# a_527_2589# 0.041843f
C2246 a_6047_2045# a_5188_2223# 0.001329f
C2247 a1 a_2157_5719# 0.086606f
C2248 a_3799_4118# a_4728_4399# 0.042678f
C2249 b1 a_1457_2767# 1.5e-22
C2250 a_2520_3855# a_2367_1135# 0.001869f
C2251 a_1455_6031# a_984_6183# 0.003052f
C2252 a_1775_4118# a_395_854# 2.8e-19
C2253 a_2263_6941# a_2235_5608# 1.21e-20
C2254 a_2375_3311# a_2235_1256# 0.001115f
C2255 b2 a_2367_5853# 0.027496f
C2256 a_1435_4765# a_1788_4765# 2.18e-19
C2257 a_4667_591# a_3847_3855# 1e-21
C2258 a0 a_1907_5309# 0.015117f
C2259 a_2417_4625# a_2263_5309# 8.66e-20
C2260 b3 a_2244_2767# 2.5e-20
C2261 a_3297_6397# a3 3.04e-20
C2262 a_297_3017# a_573_2767# 1.58e-19
C2263 a_5923_2223# a_6412_4007# 1.8e-19
C2264 a_2249_4631# a_1692_4399# 0.007331f
C2265 a_2325_5713# b5 3.03e-20
C2266 a_3799_4118# a_3072_3311# 0.788789f
C2267 a_4073_4625# a_3847_3855# 0.013271f
C2268 b0 a_1823_4943# 0.00111f
C2269 a_3387_6031# a1 0.105002f
C2270 b4 a_1400_3677# 1.27e-19
C2271 a_4709_1929# a_1865_749# 5.96e-19
C2272 a_961_1831# P9 3.23e-20
C2273 a_3977_4943# a_2249_4631# 1.87e-19
C2274 a_553_1679# a_469_1929# 0.076321f
C2275 a0 a_5541_4719# 1.14e-19
C2276 a_3813_3543# a_1823_4943# 2.11e-19
C2277 a_5356_2589# a_4533_2449# 2.22e-19
C2278 a_2375_3311# a_3072_4399# 2.79e-19
C2279 b3 a_1907_3855# 5.96e-21
C2280 a_3471_6397# a_3827_6397# 0.009846f
C2281 a_3983_5608# a_4471_5487# 0.005577f
C2282 DVDD a_4640_4221# 4.94e-19
C2283 a_2467_2223# a_3164_2223# 0.054693f
C2284 a_1775_854# a_1039_1942# 4.28e-20
C2285 a_2045_2223# a_3571_2767# 3.99e-20
C2286 DVDD a_3931_3855# 0.001484f
C2287 a_2375_4399# a_849_3017# 7.88e-21
C2288 a_2815_3677# a_2045_2223# 7.01e-21
C2289 a_995_4399# a_3164_2223# 4.65e-20
C2290 a4 a_4728_4399# 0.018706f
C2291 a_1865_4013# a_3847_3855# 0.662079f
C2292 a_1823_3855# a_3072_3311# 5.86e-20
C2293 a_5356_2223# a_3663_1135# 5.21e-20
C2294 a_1308_2589# a_883_2589# 8.12e-20
C2295 a4 a_4709_1929# 6.11e-19
C2296 a_2815_3677# a_1037_4625# 1.25e-19
C2297 a1 a_6644_4943# 2.27e-19
C2298 a_5587_3133# a_5545_2925# 0.089278f
C2299 a_995_4399# a_3905_5719# 1.35e-21
C2300 a_961_1831# a_1952_1679# 3.22e-19
C2301 a3 a_297_3855# 4.53e-21
C2302 a_1039_1942# a_573_4105# 0.247407f
C2303 a_1907_4943# a_2263_4943# 0.008475f
C2304 a_849_3017# a_849_4105# 0.002098f
C2305 a_259_1831# a_1604_1135# 4.35e-21
C2306 a_2157_5719# a_2417_4625# 0.001599f
C2307 a_2616_6575# b0 5.02e-20
C2308 a4 a_3072_3311# 9.25e-20
C2309 a_4023_3311# a_3072_3311# 6.12e-19
C2310 a_4732_3311# a_1865_4013# 1.54e-20
C2311 a_1987_3133# a_1508_1135# 2.2e-20
C2312 b1 a_1125_6895# 5.27e-19
C2313 a2 a_2193_5853# 1.71e-19
C2314 a_627_5487# a_4483_5309# 9.13e-21
C2315 b3 a_627_5487# 2.24e-19
C2316 a_1692_4399# a_1435_4399# 0.025169f
C2317 a_2157_5719# a_2367_5487# 0.011205f
C2318 a_2325_5713# DVDD 0.658732f
C2319 a_1733_3855# a_1508_1135# 6.46e-20
C2320 a_4011_2767# a_4364_2767# 2.18e-19
C2321 a_4023_3311# a_4379_3311# 0.009846f
C2322 b2 a_445_3677# 2.52e-20
C2323 a_2980_5487# a0 0.123671f
C2324 a3 a_1328_3677# 3.16e-19
C2325 a_1784_1679# a_1865_749# 5.67e-19
C2326 a5 a_619_3677# 0.0044f
C2327 a_317_2455# a_527_591# 1.33e-19
C2328 a_1784_1679# a_1823_3855# 0.001213f
C2329 a_2235_5608# a_3905_5719# 0.045355f
C2330 a_1455_6031# b3 0.004581f
C2331 a2 a_3471_6031# 7.95e-20
C2332 a_5219_6031# a_5575_6031# 0.008475f
C2333 a_3983_5608# a_2375_4399# 1.21e-20
C2334 a_4931_2589# a_1775_854# 0.036237f
C2335 a_2907_2223# a_317_743# 3.77e-21
C2336 b1 a_4728_4399# 6.8e-19
C2337 a_5095_1929# a_3663_1135# 0.004025f
C2338 a_4625_749# a_6828_1679# 0.001132f
C2339 a_2980_5487# a_2723_5487# 0.024609f
C2340 a_4533_2449# a_5188_2223# 0.069672f
C2341 a_317_743# a_395_854# 1.48022f
C2342 a_4073_4625# a_4544_3855# 0.013915f
C2343 a_3799_4118# a_4287_4221# 0.015302f
C2344 a4 a_1784_1679# 0.001325f
C2345 a3 a_259_1831# 1.89e-20
C2346 a_3747_6575# a_1775_6696# 0.030274f
C2347 a_2249_4631# a_2285_4399# 5.12e-20
C2348 a_961_1831# a_1171_2045# 0.013138f
C2349 a_395_2344# a_317_2455# 0.887779f
C2350 a_297_3017# a_355_1653# 1.55e-19
C2351 DVDD a_3827_2045# 0.156112f
C2352 DVDD a_2688_4221# 4.72e-19
C2353 a_3983_4520# a_3931_3855# 1.71e-21
C2354 a_3799_4118# a_3891_3432# 0.013163f
C2355 a_395_2344# a_248_4631# 0.001169f
C2356 a_297_3017# a_947_4520# 6.65e-19
C2357 a_1039_1942# a_1125_2767# 3.59e-20
C2358 a_984_6183# DVDD 0.344343f
C2359 P8 a_5075_1148# 0.036605f
C2360 a_4667_957# a_3663_1135# 0.00265f
C2361 P9 a_443_591# 0.056246f
C2362 b0 a_5192_4943# 8.34e-20
C2363 b1 a_3072_3311# 0.001766f
C2364 a5 a_2244_2767# 0.005359f
C2365 a_1823_6575# a_1775_4118# 6.2e-19
C2366 a_4667_591# a_443_591# 0.001495f
C2367 a_4544_3855# a_1865_4013# 0.03259f
C2368 a_3931_4221# a_3072_3311# 0.012433f
C2369 a_849_3855# a_573_4105# 2.3e-19
C2370 a_3757_4221# a_3847_3855# 0.006823f
C2371 a_1527_2045# a_1784_1679# 0.02283f
C2372 a_4751_1831# a_5873_2045# 1.2e-20
C2373 a_1697_743# a_5177_1929# 9.85e-19
C2374 a_4847_1653# a_5345_1929# 0.074134f
C2375 b4 a_4896_5487# 2.83e-21
C2376 b4 a_1775_4118# 0.029839f
C2377 a_3260_2589# a_1125_3017# 1.37e-19
C2378 a_3757_3855# a_1865_4013# 0.001008f
C2379 a_219_1929# a_469_1929# 0.025037f
C2380 a5 a_1907_3855# 0.00447f
C2381 b3 a_1125_3017# 0.001647f
C2382 a_527_2223# a_961_1831# 2.96e-20
C2383 a_2375_4399# a_1329_6183# 8.65e-21
C2384 a5 a_6092_3855# 4.44e-20
C2385 a_1508_1135# a_1604_1135# 0.004869f
C2386 a2 a_4636_3311# 0.02827f
C2387 a_757_6281# a_409_3543# 5.72e-19
C2388 a_6173_2223# a_4268_2767# 1.41e-19
C2389 a_3983_5608# a_4252_6031# 2.58e-19
C2390 b3 b5 0.041331f
C2391 a_4728_4399# a_5779_4943# 1.66e-19
C2392 a_4847_1653# a_5227_3855# 1.02e-20
C2393 a_1697_743# a_3847_3855# 0.01331f
C2394 a_1421_2919# a_2263_3855# 4.08e-21
C2395 a_3164_2223# a_2341_2455# 0.184544f
C2396 a_4023_3311# a_3891_3432# 0.030394f
C2397 a_4709_1929# a_5779_4943# 2.28e-20
C2398 a4 a_3891_3432# 0.126925f
C2399 a3 a_3148_5487# 6.88e-20
C2400 a_6047_2045# a_6403_2045# 0.009846f
C2401 a_481_6281# a_1823_6575# 0.026672f
C2402 a_4115_5487# a_2235_5608# 0.002393f
C2403 a_1865_749# a_4860_1367# 1.13e-19
C2404 a_1865_4013# a_443_591# 3.79e-19
C2405 a3 a_1400_3311# 2.26e-20
C2406 a_4103_6941# a_3261_6183# 3.52e-20
C2407 a_4457_743# a_2244_2767# 1.15e-19
C2408 a4 a_975_3311# 0.002368f
C2409 a_627_5487# a_1420_5487# 4.35e-21
C2410 a_2235_1256# a_849_3017# 9.65e-22
C2411 a_1692_4399# a_1823_4943# 0.497181f
C2412 a_5227_3855# a_5653_5095# 0.20509f
C2413 DVDD a_6173_2223# 0.251698f
C2414 a_5503_2767# a_5075_1148# 7.17e-20
C2415 a_3164_2223# a_2980_1135# 3.26e-20
C2416 a_6412_4007# a_4399_4943# 2.1e-20
C2417 a_961_1831# a_1697_743# 0.001387f
C2418 a_627_5487# a_1420_5853# 2.2e-19
C2419 P10 a_1865_749# 0.026812f
C2420 a_2263_6575# b2 3.7e-19
C2421 a_6412_4007# a_6756_2045# 0.005403f
C2422 a_3241_4943# a_4399_4943# 5.54e-21
C2423 a_763_1256# a_685_1367# 0.962708f
C2424 a1 a_3517_5487# 0.032725f
C2425 a5 a_627_5487# 9.52e-19
C2426 a_1037_4625# a_2375_4399# 6.78e-19
C2427 a_995_4399# a_2249_4631# 8.21e-19
C2428 a_5448_591# a_395_854# 1.52e-21
C2429 a_5023_591# a_1865_749# 0.029056f
C2430 a_1435_4765# a_573_4105# 5.51e-21
C2431 a_3571_2767# a_1775_4118# 7.88e-20
C2432 a_2045_2223# a_849_4105# 8.99e-19
C2433 b0 a_6000_6397# 4.89e-20
C2434 P1 a_1236_5309# 0.004869f
C2435 a_2375_3311# a_2244_2767# 9.36e-19
C2436 a_1497_6189# a_1492_5853# 8.84e-20
C2437 b5 a_527_5309# 2.63e-19
C2438 a3 a_1508_1135# 0.121076f
C2439 DVDD a_883_4943# 0.046154f
C2440 a_1037_4625# a_849_4105# 0.021797f
C2441 a_3827_6397# a_3983_5608# 1.03e-19
C2442 a_1455_6031# a5 0.003359f
C2443 a_5002_1501# a_3663_1135# 5.79e-19
C2444 a_1539_6031# a_1895_6031# 0.008475f
C2445 a_5081_2767# b5 5.16e-19
C2446 a_5009_6183# a_5135_6031# 0.891974f
C2447 DVDD a_4483_5309# 0.150024f
C2448 DVDD a_3260_2589# 1.77e-20
C2449 DVDD b3 1.38936f
C2450 a_2723_1135# a_3076_1135# 2.18e-19
C2451 a_3471_2045# a_1865_4013# 1.07e-20
C2452 b1 a_4287_4221# 2.61e-19
C2453 a_2520_3855# a_1865_749# 0.151303f
C2454 a_1823_3855# a_2520_3855# 0.307904f
C2455 a_1865_4013# a_2616_4221# 2.3e-19
C2456 a1 a_3799_4118# 0.071713f
C2457 a_4636_3311# a_5311_3855# 2.56e-19
C2458 a_3931_4221# a_4287_4221# 0.009846f
C2459 a_2045_2223# a_2815_3311# 1.41e-20
C2460 DVDD a_3076_5487# 4.94e-19
C2461 DVDD a_1328_3311# 7.75e-19
C2462 a_3891_3432# a_3931_4221# 3.16e-21
C2463 a_2249_4631# a_2235_5608# 0.001173f
C2464 a_5002_1174# a_3663_1135# 3.82e-19
C2465 a_5081_2767# a_4268_2767# 5.86e-20
C2466 a4 a_2520_3855# 0.061979f
C2467 a_4636_3311# a_4732_3677# 0.005644f
C2468 a_4528_6575# P3 0.007578f
C2469 b2 a_2907_2223# 3.16e-21
C2470 a1 a_1823_3855# 1.66e-20
C2471 a5 a_485_749# 1.41e-21
C2472 b0 a_2616_6941# 1.12e-19
C2473 a_883_5309# a_1236_5309# 2.18e-19
C2474 a_3168_3677# a_2249_3543# 8.59e-19
C2475 a_1697_743# a_4544_3855# 5.37e-21
C2476 a_1907_6575# a2 0.032163f
C2477 a_3609_4399# a_4896_4765# 3.15e-19
C2478 a_4073_4625# a_4471_4765# 0.045487f
C2479 a_995_4399# a_1435_4399# 0.004048f
C2480 a_3799_4118# a_4115_4765# 0.070964f
C2481 a_3517_5807# a_4031_5487# 2.54e-20
C2482 a_3983_4520# a_4824_4765# 0.001106f
C2483 a1 a_1907_4943# 0.002f
C2484 b0 a_3537_6807# 0.087057f
C2485 a_961_1831# a_1907_591# 8.88e-21
C2486 a_573_2767# a_409_3543# 0.009374f
C2487 a_3517_5487# a_2417_4625# 1.54e-19
C2488 a_2723_5853# a_2235_5608# 0.008624f
C2489 a_317_743# a_1251_1135# 0.002734f
C2490 a_2367_5853# a_2283_5487# 0.061962f
C2491 a5 a_1125_3017# 0.031332f
C2492 P1 a_1823_6575# 4.58e-19
C2493 a_3983_5608# a_3072_4399# 0.005163f
C2494 DVDD a_527_5309# 0.284467f
C2495 a_2248_6397# b0 1.03e-19
C2496 a_501_5719# a2 0.039776f
C2497 a1 a_4023_3311# 1.71e-20
C2498 P4 a_5779_4943# 4.46e-21
C2499 a5 b5 3.01308f
C2500 DVDD a_4896_4399# 4.72e-19
C2501 b2 P5 0.063852f
C2502 a1 a4 0.035147f
C2503 DVDD P7 0.256528f
C2504 a_5311_4221# a_1823_4943# 0.003802f
C2505 b4 a_3523_3030# 0.113245f
C2506 a_4544_3855# a_5821_5101# 3.27e-21
C2507 a_1497_6189# b0 0.007186f
C2508 a1 a_5219_6031# 3.85e-21
C2509 a_757_6281# a_975_3677# 4.23e-20
C2510 a_2285_4399# a_1823_4943# 4.01e-20
C2511 a_2467_2223# a_4103_1135# 1.21e-20
C2512 a_4535_854# a_395_854# 1.78e-19
C2513 a_5376_591# DVDD 6.85e-21
C2514 a_3891_3432# a_5779_4943# 0.040238f
C2515 a_4931_2223# a_3847_3855# 0.015269f
C2516 a_4896_5487# a_4471_5487# 1.31e-19
C2517 a_1697_743# a_443_591# 0.014025f
C2518 a_5863_4943# a_5227_3855# 3.17e-20
C2519 a_2459_3311# a_1775_4118# 5.74e-19
C2520 a_3827_6031# a_2283_5487# 0.002599f
C2521 a_4401_2589# a_5188_2223# 2.79e-20
C2522 a0 a_4073_4625# 0.098618f
C2523 a_3799_4118# a_2417_4625# 0.001902f
C2524 b3 a_353_2589# 9.09e-20
C2525 a_3609_4399# a_4839_5309# 2.5e-20
C2526 b3 a_3983_4520# 0.002114f
C2527 a_2244_2767# a_2616_591# 3.91e-20
C2528 a_4847_1653# a_4252_1679# 6.83e-21
C2529 a_4751_1831# a_4709_1679# 0.009592f
C2530 a_3573_6941# a_1775_6696# 0.007263f
C2531 a_1697_743# a_4180_1679# 1.53e-19
C2532 a_5356_2223# a4 6.95e-20
C2533 a5 a_4268_2767# 8.64e-20
C2534 b1 a_2520_3855# 0.01408f
C2535 a_3571_2767# a_317_743# 2.86e-19
C2536 a_5503_2767# a_6173_1135# 5.8e-21
C2537 a_4667_591# a_4625_749# 0.033252f
C2538 a_1823_6575# a_883_5309# 1.74e-19
C2539 a2 a_4483_4943# 7.46e-19
C2540 a_2249_4631# a_2341_2455# 1.74e-22
C2541 a_1308_4943# a_883_4943# 8.12e-20
C2542 a_445_3677# a_573_4105# 2.29e-19
C2543 a_4457_743# b5 0.002837f
C2544 a0 a_1865_4013# 6.74e-20
C2545 a_1823_3855# a_2417_4625# 1.37e-19
C2546 DVDD a_1420_5487# 4.94e-19
C2547 a_2551_2589# a_1823_3855# 0.002479f
C2548 a_3072_3311# a_2327_4520# 2.36e-20
C2549 a_2467_2223# a_3148_1501# 1.32e-19
C2550 a_3471_6397# a_627_5487# 5.73e-19
C2551 a_2263_4943# a_2327_4520# 3.21e-19
C2552 a0 a_1733_4943# 2.33e-19
C2553 a_2243_1929# a_2467_2223# 2.11e-19
C2554 a_2235_1256# a_2045_2223# 0.001952f
C2555 b0 a_5503_2767# 1.4e-19
C2556 a_5188_2223# a_5289_1433# 3.42e-20
C2557 a_5923_2223# a_5075_1148# 2.69e-21
C2558 a_3471_1679# a_3827_1679# 0.008475f
C2559 a_883_2223# a4 3.47e-19
C2560 a0 P3 7.36e-19
C2561 b0 a_6412_5719# 8.81e-20
C2562 a_3523_3030# a_3571_2767# 0.133481f
C2563 b0 a3 0.473808f
C2564 b1 a1 0.317343f
C2565 a_1697_743# a_3471_2045# 0.003153f
C2566 a_2235_1256# a_4180_2045# 4.35e-21
C2567 a_4751_1831# a_3537_1367# 0.032884f
C2568 DVDD a5 1.807f
C2569 a_2375_3311# a_1125_3017# 0.005201f
C2570 a_1308_2589# a_1421_2919# 2.02e-20
C2571 a4 a_2417_4625# 2.06e-20
C2572 DVDD a_3747_1135# 0.255877f
C2573 a_1455_6031# a_3471_6397# 0.113145f
C2574 a1 a_3931_4221# 8.91e-19
C2575 a_5095_1929# a_1865_749# 2.23e-21
C2576 a0 a_5045_6031# 1.86e-19
C2577 a_2375_3311# b5 6.55e-19
C2578 a_4625_749# a_1865_4013# 2.17e-19
C2579 DVDD a_721_1135# 5.27e-19
C2580 a_2467_2223# a_1823_4943# 3.46e-21
C2581 a_4457_743# a_4268_2767# 0.015154f
C2582 a_4728_4399# a_4115_4399# 1.78e-19
C2583 a_3799_4118# a_4471_4399# 0.006527f
C2584 a_3983_4520# a_4896_4399# 2.43e-19
C2585 a_2375_4399# a_1775_4118# 0.004475f
C2586 a_2688_6575# a_1329_6183# 3.71e-21
C2587 a_995_4399# a_1823_4943# 0.104832f
C2588 a_1527_1679# a_1508_1135# 0.009004f
C2589 a_1907_591# a_443_591# 6.79e-19
C2590 a_355_1653# a_409_3543# 8.85e-19
C2591 a_4528_6941# a_3537_6807# 3.15e-19
C2592 a_4667_957# a_1865_749# 0.031033f
C2593 a_5837_1831# a_4535_854# 0.071955f
C2594 a_1733_6575# a_1823_6575# 0.006823f
C2595 a_4456_6941# a_627_5487# 7.33e-20
C2596 a_947_4520# a_409_3543# 6.8e-19
C2597 a4 a_5095_1929# 0.002501f
C2598 a_849_4105# a_1775_4118# 0.281297f
C2599 b2 a_2520_6575# 9.02e-19
C2600 a_2249_4631# a_1079_4765# 3.77e-20
C2601 a_3240_4399# a_1692_4399# 1.15e-19
C2602 a_4011_2767# a_3847_3855# 0.002087f
C2603 a_961_1831# a_895_1501# 1.82e-19
C2604 a_4805_2767# a_1865_4013# 5.28e-19
C2605 a_849_3017# a_2244_2767# 0.07391f
C2606 a_3072_3311# a_4115_4399# 4.64e-20
C2607 a_6020_3855# a_1692_4399# 2.54e-19
C2608 DVDD a_4457_743# 1.0556f
C2609 b2 a_1823_6575# 0.167515f
C2610 a_2375_3311# a_4268_2767# 0.060313f
C2611 a_1365_6397# a_627_5487# 4.66e-20
C2612 a_3523_3030# a_3655_3133# 0.027192f
C2613 a_3813_3543# a_4011_3133# 9.98e-19
C2614 a_1895_6397# a_1823_6575# 0.004399f
C2615 a_2980_5487# a_4103_6941# 1.21e-20
C2616 DVDD a_6005_1135# 0.006144f
C2617 a1 a_5779_4943# 0.034322f
C2618 a_481_6281# a_2375_4399# 5.97e-21
C2619 b2 b4 0.835846f
C2620 a_2243_1929# a_2325_1929# 0.006406f
C2621 a_849_3017# a_1907_3855# 5.27e-20
C2622 DVDD a_1236_2223# 4.94e-19
C2623 a_4436_2767# a4 1.44e-19
C2624 a_1823_4943# a_2235_5608# 0.007714f
C2625 a_1497_6189# a_1539_6397# 0.089637f
C2626 a0 a_1365_6031# 1.67e-19
C2627 a_1455_6031# a_1365_6397# 0.006861f
C2628 a_2493_1929# a_2520_3855# 0.006344f
C2629 a_259_1831# a_721_1501# 0.007261f
C2630 a_2263_4221# a_2520_3855# 0.02283f
C2631 b1 a_2417_4625# 0.052853f
C2632 a_5345_1929# a_3663_1135# 0.00199f
C2633 a_4103_6575# a_4456_6575# 2.18e-19
C2634 DVDD a_2375_3311# 1.25504f
C2635 a3 a_685_1367# 0.00301f
C2636 a_4931_2223# a_443_591# 3.97e-20
C2637 a5 a_3983_4520# 6.02e-20
C2638 a_297_3017# b3 0.051413f
C2639 a_895_1135# a_1251_1135# 0.009846f
C2640 a_5135_6031# a_4728_4399# 5.82e-20
C2641 a_3983_5608# a_4471_5853# 0.009792f
C2642 a_2616_591# a_485_749# 3.73e-20
C2643 b4 a_4535_854# 3.36e-19
C2644 a_2263_591# a_1865_749# 0.045338f
C2645 a_1823_3855# a_2263_591# 1.27e-20
C2646 a_3523_3030# a_2459_3311# 1.51e-20
C2647 a_4103_1135# a_2980_1135# 2.98e-19
C2648 a_6412_4007# a_6828_1679# 0.00792f
C2649 a2 a_4732_3677# 1.08e-19
C2650 a_4268_2767# a_5023_957# 3.74e-21
C2651 a_5227_3855# a_3663_1135# 6.21e-19
C2652 a_395_2344# a_975_3311# 0.004335f
C2653 a_297_3017# a_1328_3311# 4.95e-20
C2654 a_2907_2589# a_1697_743# 2.91e-19
C2655 a_4103_6575# a1 2.09e-19
C2656 a_1497_6189# a_1692_4399# 3.96e-19
C2657 b4 a_4309_4943# 2.69e-19
C2658 DVDD a_1676_1501# 1.71e-19
C2659 a_997_2045# a_685_1367# 3.44e-20
C2660 a2 a_2263_6941# 6.04e-19
C2661 a1 a_711_5487# 0.00373f
C2662 a_757_6281# a_1823_3855# 5.14e-20
C2663 a_4528_6941# a3 1.86e-21
C2664 P9 a_883_591# 0.023012f
C2665 a_757_6281# a_1907_4943# 9.98e-19
C2666 a1 a_711_5853# 0.004496f
C2667 a_995_4399# a_2459_4765# 1.44e-20
C2668 a_1865_4013# a_5223_1501# 3.44e-20
C2669 b2 a_3571_2767# 0.005152f
C2670 a_2907_2223# a_1775_854# 7.34e-21
C2671 a_3260_2223# a_2467_2223# 1.63e-19
C2672 a_2243_1929# a_2341_2455# 0.001122f
C2673 DVDD a_5023_957# 0.155519f
C2674 a_3332_2223# a_2045_2223# 2.56e-19
C2675 b2 a_2815_3677# 0.002631f
C2676 a_4839_5309# a_4399_4943# 0.003858f
C2677 a0 a_5821_5101# 0.003051f
C2678 a_5587_2767# a_1692_4399# 1e-19
C2679 a_6368_2767# a_5227_3855# 2.57e-20
C2680 a_1775_854# a_395_854# 0.261387f
C2681 a_4401_2223# a_3537_1367# 3.3e-20
C2682 a_757_6281# a4 1.32e-20
C2683 a_1697_743# a_4625_749# 0.004926f
C2684 a_6572_4943# a_6412_4007# 5.86e-20
C2685 a_1171_1679# a_317_743# 8.53e-19
C2686 a_5667_4221# a_6092_4221# 1.31e-19
C2687 a_3387_6031# a_6000_6031# 6.11e-20
C2688 a_5009_6183# a_5928_6031# 2.48e-20
C2689 DVDD a_3471_6397# 0.149763f
C2690 a_5135_6031# a_5575_6031# 0.051254f
C2691 a_2980_1135# a_3148_1501# 0.00792f
C2692 a_553_1679# a_2243_1929# 0.10974f
C2693 a_4751_1831# a_5075_1148# 0.324952f
C2694 a_4364_2767# a_3891_3432# 1.05e-19
C2695 a_2341_2455# a_1823_4943# 1.62e-21
C2696 a_3891_3432# a_4115_4399# 4.78e-20
C2697 a_2263_3855# a_1508_1135# 0.044609f
C2698 a_4535_854# a_3571_2767# 0.005418f
C2699 a_4625_749# a_4493_957# -1.05e-35
C2700 a_4943_1653# a_1865_4013# 0.099668f
C2701 b0 a_3609_4399# 1.16e-19
C2702 a1 a_3941_4765# 3.04e-19
C2703 a_975_3677# a_355_1653# 5.33e-21
C2704 a_961_1831# a_317_2455# 0.002546f
C2705 a_5095_1929# a_5779_4943# 6.03e-19
C2706 a_4535_854# a_4031_5487# 2.46e-20
C2707 a_5503_2767# a_1692_4399# 5.69e-19
C2708 a_2375_3311# a_3983_4520# 6.17e-21
C2709 a_4636_3311# a_2249_4631# 6.69e-22
C2710 a_975_3677# a_947_4520# 1.59e-20
C2711 a_3523_3030# a_2375_4399# 4.16e-20
C2712 a_3813_3543# a_3609_4399# 1.04e-20
C2713 a3 a_1692_4399# 0.098848f
C2714 a_2235_1256# a_1775_4118# 0.169585f
C2715 a_1508_1135# a_721_1501# 2.99e-20
C2716 a_2459_4765# a_2235_5608# 1.97e-19
C2717 a_2551_2223# a_3164_2223# 2.75e-19
C2718 b2 a_3655_3133# 0.00409f
C2719 a0 a_1907_4221# 6.09e-20
C2720 a_2263_4221# a_2417_4625# 7.79e-19
C2721 a_2520_3855# a_2327_4520# 0.001977f
C2722 a_2980_1135# a_1823_4943# 3.11e-19
C2723 a_1125_6895# a_1775_6696# 2.9e-20
C2724 a_1039_1942# a_395_854# 3.69e-20
C2725 b5 a_297_4105# 0.635479f
C2726 a_2325_5713# a_2263_5309# 1.75e-19
C2727 a_3747_6575# a0 4.15e-21
C2728 a3 a_3977_4943# 1.52e-20
C2729 a_3983_5608# a_627_5487# 7.33e-19
C2730 a_5045_6397# a_3537_6807# 1.29e-20
C2731 a_4483_4943# a_3905_5719# 2.43e-20
C2732 a_4839_4943# a_2283_5487# 0.045338f
C2733 a_3523_3030# a_849_4105# 0.002572f
C2734 b0 a_3148_5853# 4.61e-20
C2735 a_849_3017# a_1125_3017# 0.088356f
C2736 a_4379_3677# a_4804_3677# 8.12e-20
C2737 a_2327_3432# a_1865_4013# 0.013439f
C2738 a_1823_6575# a_2459_4399# 2.73e-20
C2739 a_317_5095# a_1823_4943# 0.002215f
C2740 a2 a_3164_2223# 2.98e-19
C2741 a_757_6281# a_1539_6031# 9.2e-22
C2742 b5 a_849_3017# 6.2e-20
C2743 a_1455_6031# a_3983_5608# 3.68e-19
C2744 a_3387_6031# a_2320_6031# 2.23e-21
C2745 a_757_6281# b1 0.122051f
C2746 a2 a_3905_5719# 0.02234f
C2747 a1 a_2327_4520# 0.0796f
C2748 a_1365_6397# DVDD 4.94e-19
C2749 a_2045_2223# a_2244_2767# 0.02719f
C2750 a_5135_6031# P4 0.046635f
C2751 a1 a_395_2344# 3.2e-20
C2752 a5 a_2249_3543# 0.168462f
C2753 a5 a_297_3017# 0.023936f
C2754 a_3523_3030# a_2815_3311# 8.93e-20
C2755 a_2375_3311# a_3240_3311# 1.5e-19
C2756 a_4535_854# a_5448_957# 2.17e-19
C2757 a5 a_2616_3855# 2.85e-19
C2758 b2 a_2459_3311# 0.004561f
C2759 a_5837_1831# a_1775_854# 2.35e-19
C2760 DVDD a_6047_2045# 0.166413f
C2761 b4 a_4379_3677# 0.004236f
C2762 a_995_4399# a_1733_3855# 6.73e-20
C2763 a_1037_4625# a_1907_3855# 0.002003f
C2764 a_1697_743# a_1907_957# 0.011205f
C2765 a_627_5487# a_1329_6183# 0.070242f
C2766 a_1823_6575# a_1907_6941# 0.062852f
C2767 a_2325_5713# a_2157_5719# 0.624899f
C2768 a_3941_5853# a_2283_5487# 2.33e-19
C2769 a_4533_2449# a_5943_2767# 3.78e-19
C2770 a_4115_5853# a_2235_5608# 5.61e-19
C2771 a_3747_6941# a_3517_5487# 0.035963f
C2772 a5 a_4847_1653# 3.02e-22
C2773 b3 a_3240_4765# 0.001147f
C2774 a_1697_743# a_3573_1135# 1.71e-20
C2775 a4 a_1987_2767# 0.00821f
C2776 a_1527_1679# a_685_1367# 0.002823f
C2777 a_961_1831# a_1457_2767# 3.38e-19
C2778 a_2320_6397# a_1329_6183# 6.73e-20
C2779 DVDD a_297_4105# 1.42216f
C2780 a_1697_743# a_5223_1501# 5.01e-19
C2781 a_2263_957# a_2688_957# 1.31e-19
C2782 a4 a_573_2767# 6.2e-19
C2783 a_1455_6031# a_1329_6183# 0.729508f
C2784 a5 a_5653_5095# 0.001831f
C2785 a_3387_6031# a_2325_5713# 0.009575f
C2786 a_3260_2223# a_2341_2455# 1.11e-19
C2787 a1 a_4115_4399# 0.002814f
C2788 a_353_4943# a_443_4943# 0.006958f
C2789 a_317_2455# a_443_591# 3.88e-20
C2790 a_5413_3133# a_5503_2767# 0.006823f
C2791 DVDD a_849_3017# 0.702792f
C2792 a_4931_2223# a_4625_749# 4.28e-22
C2793 a_763_1256# a_553_1679# 0.095867f
C2794 a_763_1256# a_2980_1135# 2.65e-21
C2795 a_5667_4221# a_4031_5487# 0.020484f
C2796 a_5587_3133# a_4031_5487# 5.27e-20
C2797 a_2327_4520# a_2417_4625# 0.749748f
C2798 a3 a_2285_4399# 3.25e-20
C2799 a_883_2223# a_395_2344# 0.017703f
C2800 a_984_6183# a_2157_5719# 2.23e-19
C2801 a_1037_4625# a_627_5487# 5.7e-20
C2802 a_4533_2449# b5 0.135949f
C2803 a_4457_743# a_4847_1653# 0.025131f
C2804 a_4943_1653# a_1697_743# 0.008315f
C2805 a_1769_2543# b3 2.25e-19
C2806 a2 a_4115_5487# 0.004737f
C2807 b5 a_4640_3855# 1.25e-19
C2808 a_4751_1831# a_6173_1135# 0.112559f
C2809 a_2235_1256# a_317_743# 0.00445f
C2810 b2 a_2375_4399# 3.49e-19
C2811 a_3827_2045# a_3663_1135# 1.77e-19
C2812 a_501_5719# a_2249_4631# 3.16e-22
C2813 a_2375_3311# a_2249_3543# 0.794048f
C2814 a_297_3017# a_2375_3311# 5.22e-20
C2815 b4 a_997_1679# 2.73e-21
C2816 a_2327_4520# a_2367_5487# 3.89e-21
C2817 a_4839_5309# a_4351_5206# 0.009397f
C2818 a0 a_4896_5853# 2.47e-19
C2819 a_1497_6189# a_995_4399# 6.13e-20
C2820 a_1775_854# a_1251_1135# 6.13e-19
C2821 b2 a_849_4105# 0.078214f
C2822 b4 a_573_4105# 0.104913f
C2823 a_4457_743# a_5653_5095# 9.87e-21
C2824 a_2520_3855# a_3076_1135# 1.44e-19
C2825 a3 a_1733_6941# 2.96e-21
C2826 a_4535_854# a_5188_2223# 0.004382f
C2827 a_3537_1367# a_3747_1501# 0.04028f
C2828 a_757_6281# a_711_5487# 1.25e-19
C2829 a_2520_6575# a_2283_5487# 3.23e-20
C2830 b2 a_3076_5853# 1.02e-19
C2831 a_3523_3030# a_2235_1256# 2.14e-20
C2832 a_4103_6941# P3 0.023012f
C2833 a_2327_3432# a_1697_743# 4.96e-22
C2834 a_4533_2449# a_4268_2767# 0.489933f
C2835 a_2375_4399# a_4535_854# 2.08e-20
C2836 a_5923_2223# a_1692_4399# 1.27e-21
C2837 a_1823_6575# a_2283_5487# 0.028585f
C2838 a_3537_6807# a_2235_5608# 0.001869f
C2839 b4 a_1039_1942# 0.013326f
C2840 a_2249_4631# a_1860_4765# 3.83e-20
C2841 a_3609_4399# a_1692_4399# 0.004373f
C2842 a_1895_6031# a_1775_6696# 7.93e-20
C2843 a_4073_4625# a_6412_4007# 1.72e-19
C2844 b0 a_4399_4943# 0.050784f
C2845 a_3799_4118# a_5227_3855# 4.41e-19
C2846 a_5135_6031# a1 8.4e-19
C2847 a_2045_2223# a_485_749# 5.51e-21
C2848 b4 a_2283_5487# 0.045327f
C2849 a_4709_1929# a_3847_3855# 0.004021f
C2850 a_2723_1501# a_3148_1501# 8.12e-20
C2851 b2 a_2815_3311# 0.005918f
C2852 DVDD a_3983_5608# 1.60885f
C2853 a_3813_3543# a_4399_4943# 4.57e-21
C2854 a_4636_3311# a_1823_4943# 1.71e-19
C2855 a_4483_4943# a_2249_4631# 0.002832f
C2856 a_4115_4399# a_2417_4625# 1.35e-19
C2857 a_3523_3030# a_3072_4399# 6.44e-20
C2858 a_2235_1256# a_2367_1501# 0.021103f
C2859 a_947_4520# a_1823_3855# 0.026343f
C2860 a_1039_1942# a_1251_1135# 1.08e-19
C2861 a_2243_1929# a_2723_1501# 0.001009f
C2862 a_1497_6189# a_2235_5608# 0.001342f
C2863 DVDD a_5137_4221# 4.94e-19
C2864 b3 a_409_3543# 0.02236f
C2865 DVDD a_4533_2449# 0.51504f
C2866 a_1775_854# a_3571_2767# 0.321918f
C2867 a_2045_2223# a_1125_3017# 0.798864f
C2868 DVDD a_1860_4399# 4.72e-19
C2869 a_2377_2223# a_849_4105# 3.11e-21
C2870 a_1775_854# a_4031_5487# 1.44e-21
C2871 a_501_5719# a_1435_4399# 5.73e-21
C2872 a_6173_2223# a_3663_1135# 7.95e-19
C2873 a_3072_3311# a_3847_3855# 0.794484f
C2874 a2 a_2249_4631# 0.127992f
C2875 b5 a_2045_2223# 4e-21
C2876 a3 a_995_4399# 0.26448f
C2877 a4 a_355_1653# 0.002036f
C2878 a4 a_5345_1929# 0.001317f
C2879 a_5837_1831# a_5545_2925# 0.058545f
C2880 a4 a_947_4520# 0.163839f
C2881 P0 a_248_4631# 0.05166f
C2882 b5 a_1037_4625# 0.029685f
C2883 a_3241_4943# a_1865_4013# 3.69e-20
C2884 a_2263_4943# a_2616_4943# 2.18e-19
C2885 b4 a_1125_2767# 6.54e-20
C2886 a_1421_2919# a_1865_4013# 5.88e-21
C2887 a_3261_6183# b0 0.021677f
C2888 a_4379_3311# a_3847_3855# 0.002163f
C2889 a4 a_5227_3855# 0.203405f
C2890 b3 a_2157_5719# 0.024255f
C2891 a_2244_2767# a_1775_4118# 0.035614f
C2892 a_5837_1831# a_5923_1135# 2.47e-19
C2893 DVDD a_1329_6183# 0.803672f
C2894 a_317_5095# a_1308_5309# 1.05e-19
C2895 a_685_1367# a_721_1501# 4.78e-19
C2896 a_2467_2223# a_4011_3133# 8.84e-22
C2897 a_2045_2223# a_4268_2767# 3.45e-21
C2898 a_219_1929# a_763_1256# 0.00213f
C2899 a_1907_3855# a_1775_4118# 0.018277f
C2900 a_4379_3311# a_4732_3311# 2.18e-19
C2901 a_4115_4399# a_4471_4399# 0.009846f
C2902 a3 a_1769_3631# 1.42e-19
C2903 a_5009_6183# a0 0.047055f
C2904 a_757_6281# a_2327_4520# 2.58e-19
C2905 a_3537_1367# a_4364_3133# 1.89e-20
C2906 a3 a_2235_5608# 0.034705f
C2907 a5 a_1769_2543# 8.25e-20
C2908 a_2235_5608# a_6412_5719# 2.09e-19
C2909 a_2283_5487# a_4031_5487# 0.038536f
C2910 a_3387_6031# b3 5.51e-19
C2911 a_4457_743# a_4575_2223# 1e-21
C2912 a_4943_1653# a_4931_2223# 0.03294f
C2913 a_757_6281# a_395_2344# 1.36e-20
C2914 a_5575_6031# a_5928_6031# 2.18e-19
C2915 b4 a_5545_2925# 6.76e-19
C2916 a_3983_5608# a_3983_4520# 0.003212f
C2917 a_2980_5487# a_3148_5487# 0.007784f
C2918 DVDD a_2045_2223# 1.04782f
C2919 b5 a_905_4399# 2.73e-20
C2920 a_4073_4625# a_4712_4221# 1.55e-19
C2921 b1 a_947_4520# 0.375247f
C2922 a0 a_248_4631# 0.104728f
C2923 a_5587_3133# a_2375_4399# 7.57e-21
C2924 a_4728_4399# a_4544_3855# 0.00185f
C2925 a_3799_4118# a_4640_4221# 3.03e-19
C2926 a_2375_4399# a_5667_4221# 0.083038f
C2927 DVDD a_1037_4625# 0.662536f
C2928 a_4709_1929# a_4544_3855# 1.25e-20
C2929 a_4456_6575# a_1775_6696# 4.35e-21
C2930 a_2249_4631# a_2815_4399# 0.012633f
C2931 a_2375_4399# a_2459_4399# 0.030161f
C2932 b2 a_2235_1256# 2.11e-20
C2933 DVDD a_4180_2045# 6.04e-19
C2934 a_3799_4118# a_3931_3855# 0.017809f
C2935 a_961_1831# a_1784_1679# 0.133101f
C2936 P11 a_2243_1929# 0.166001f
C2937 a_2325_5713# a_3517_5487# 2.74e-19
C2938 P8 a_2980_1135# 6.92e-21
C2939 b1 a_5227_3855# 7.28e-20
C2940 a_849_4105# a_2459_4399# 5.48e-20
C2941 a_1604_1135# a_2980_1135# 4.29e-21
C2942 a_4493_591# a_2980_1135# 7.93e-19
C2943 P7 a_3663_1135# 0.004555f
C2944 a_2412_2767# a_1823_3855# 1.98e-19
C2945 a_4287_4221# a_3847_3855# 0.003859f
C2946 a_4544_3855# a_3072_3311# 0.157377f
C2947 a_297_3017# a_297_4105# 0.0129f
C2948 a_1784_1679# a_1880_2045# 0.004869f
C2949 a_1527_2045# a_1952_2045# 1.31e-19
C2950 a_3891_3432# a_3847_3855# 0.113778f
C2951 a_3931_3855# a_1823_3855# 4.59e-21
C2952 b2 a_3072_4399# 1.16e-19
C2953 a_4287_3855# a_1865_4013# 0.036295f
C2954 a_3757_3855# a_3072_3311# 2.22e-19
C2955 a1 a_1775_6696# 6.86e-20
C2956 a_5376_591# a_3663_1135# 6.84e-20
C2957 b3 a_1631_3133# 5.14e-20
C2958 a5 a_3655_2767# 7.16e-20
C2959 a_6219_5309# a_2283_5487# 7.36e-20
C2960 a_4709_1929# a_443_591# 0.161765f
C2961 a5 a_409_3543# 0.154662f
C2962 a_849_3017# a_2249_3543# 9.65e-20
C2963 a_4379_3311# a_4544_3855# 1.9e-19
C2964 a_297_3017# a_849_3017# 0.009294f
C2965 a_3240_3677# a_1865_4013# 3.01e-19
C2966 a_975_3677# b3 0.003818f
C2967 a_1697_743# a_6412_4007# 3.25e-19
C2968 a_2412_2767# a4 1.46e-19
C2969 a_5345_1929# a_5779_4943# 9.09e-19
C2970 a_2551_2223# a_2243_1929# 0.001107f
C2971 a_4732_3311# a_3891_3432# 3.5e-19
C2972 a_5503_2767# a_2341_2455# 2.72e-19
C2973 a_4471_5487# a_2283_5487# 5.71e-19
C2974 a_4115_5487# a_3905_5719# 0.016813f
C2975 a_3941_5487# a_4031_5487# 0.006823f
C2976 a_4824_5487# a_2235_5608# 1.6e-20
C2977 a_481_6281# a_627_5487# 0.032134f
C2978 a_3847_3855# a_4860_1367# 3.05e-19
C2979 a_5545_2925# a_4031_5487# 0.002072f
C2980 b0 a_4351_5206# 0.004404f
C2981 b5 a_5173_3631# 1.68e-19
C2982 DVDD a_905_4399# 4.94e-19
C2983 a_961_1831# a_975_3311# 0.024132f
C2984 a_2244_2767# a_317_743# 4.97e-20
C2985 a_2320_6397# a_481_6281# 2.96e-19
C2986 a_1692_4399# a_4399_4943# 0.002161f
C2987 a_1697_743# a_1421_2919# 5.21e-20
C2988 a_3813_3543# a_4351_5206# 8.93e-21
C2989 a_5227_3855# a_5779_4943# 0.027815f
C2990 a_6412_4007# a_5821_5101# 0.001397f
C2991 a_5503_2767# a_2980_1135# 3.56e-21
C2992 a_355_1653# a_527_2589# 0.066113f
C2993 a_1775_854# a_5188_2223# 0.063417f
C2994 a_627_5487# a_1861_5807# 1.16e-20
C2995 a5 a_2157_5719# 1.21e-22
C2996 a_1823_6575# a_2367_5853# 1.03e-20
C2997 a_317_2455# a_883_2589# 0.044609f
C2998 a3 a_553_1679# 8.5e-20
C2999 a_1455_6031# a_481_6281# 0.374065f
C3000 a_1865_4013# a_4709_1679# 1.17e-19
C3001 a_1775_4118# a_485_749# 6.82e-20
C3002 a_4309_4943# a_3072_4399# 7.85e-19
C3003 a_3977_4943# a_4399_4943# 9.37e-20
C3004 a_4401_2589# a_4268_2767# 7.47e-19
C3005 a_995_4399# a_3609_4399# 0.020379f
C3006 a_395_2344# a_1251_1501# 3.73e-20
C3007 b0 a_1907_5309# 4.71e-19
C3008 a_1125_3017# a_1775_4118# 0.024989f
C3009 a_395_2344# a_573_2767# 1.8e-19
C3010 a_1775_854# a_849_4105# 3.59e-21
C3011 a_3747_1135# a_3663_1135# 0.037333f
C3012 a_3523_3030# a_2244_2767# 0.002313f
C3013 a_1497_6189# a_2193_5853# 2.28e-19
C3014 a_4931_2589# a_5356_2589# 8.12e-20
C3015 a2 a_1823_4943# 0.027714f
C3016 a_2375_4399# a_573_4105# 7.38e-22
C3017 a3 a_317_5095# 2.25e-19
C3018 a_1895_6031# a_2248_6031# 2.18e-19
C3019 b5 a_1775_4118# 0.062195f
C3020 a_3537_6807# a_3471_6031# 7.47e-20
C3021 a_553_1679# a_997_2045# 8.16e-20
C3022 b0 a_5541_4719# 6.69e-19
C3023 a_763_1256# a_883_957# 5.51e-19
C3024 DVDD a_5192_5309# 4.94e-19
C3025 a_1784_1679# a_443_591# 7.01e-20
C3026 a_3537_1367# a_1865_4013# 0.041254f
C3027 a_2375_3311# a_3655_2767# 0.033252f
C3028 a_3847_3855# a_2520_3855# 5.01e-20
C3029 a_573_4105# a_849_4105# 0.023582f
C3030 a1 a_573_4719# 8.74e-20
C3031 a_2375_3311# a_409_3543# 1.38e-19
C3032 a_4268_2767# a_5289_1433# 8.07e-21
C3033 a_4287_4221# a_4544_3855# 0.02283f
C3034 a_2249_4631# a_3164_2223# 8.54e-21
C3035 b4 a_1079_4399# 4.93e-21
C3036 DVDD a_5265_5807# 2.63e-19
C3037 a_1171_1679# a_1039_1942# 0.017809f
C3038 a_2467_2223# a_3168_3311# 3.39e-20
C3039 a_3261_6183# a_3977_4943# 3.81e-20
C3040 a_1308_2589# a_685_1367# 0.00801f
C3041 a_3891_3432# a_4544_3855# 0.070604f
C3042 a_2459_3677# a_2249_4631# 5.62e-21
C3043 a_2375_4399# a_2283_5487# 4.77e-19
C3044 b2 a_2815_4765# 4.33e-21
C3045 a_2249_4631# a_3905_5719# 0.003855f
C3046 a_3609_4399# a_2235_5608# 2.28e-20
C3047 a_763_1256# P11 5.4e-20
C3048 a_4457_743# a_3663_1135# 0.047936f
C3049 a3 a_573_3855# 6.99e-20
C3050 a_1039_1942# a_849_4105# 1.35e-20
C3051 a_6005_1135# a_3663_1135# 0.00864f
C3052 b1 a_3168_3677# 2.01e-19
C3053 a_984_6183# a4 9.45e-21
C3054 a1 a_3847_3855# 2.14e-20
C3055 a_961_1831# a_2520_3855# 6.45e-20
C3056 b0 a_3241_6895# 2.94e-20
C3057 a_4533_2449# a_4847_1653# 2.07e-20
C3058 a_4728_4399# a_4471_4765# 0.023012f
C3059 a_3799_4118# a_4824_4765# 2.93e-20
C3060 a1 a_2616_4943# 1.06e-19
C3061 DVDD a_5289_1433# 0.190374f
C3062 a_3076_5853# a_2283_5487# 3e-19
C3063 a_317_743# a_1676_1135# 9.14e-20
C3064 a_3148_5853# a_2235_5608# 6.11e-20
C3065 a5 a_1631_3133# 2.85e-19
C3066 P1 a_627_5487# 0.0014f
C3067 b3 a_3517_5487# 0.092221f
C3068 a_2325_5713# a_1539_6031# 1.87e-20
C3069 a_481_6031# b0 2.85e-19
C3070 a_2325_5713# b1 1e-19
C3071 a_2375_3311# a_3663_1135# 2.6e-19
C3072 DVDD a_1775_4118# 1.14772f
C3073 a_6020_4221# a_1823_4943# 1.19e-19
C3074 a5 a_975_3677# 0.003303f
C3075 a_2815_4399# a_1823_4943# 0.002625f
C3076 DVDD a_4896_5487# 6.64e-19
C3077 b2 a_619_3677# 3.52e-19
C3078 a_5943_3133# a_1823_4943# 4.74e-21
C3079 a_2459_4399# a_3072_4399# 2.61e-19
C3080 a_2980_5487# b0 7.83e-19
C3081 a_355_1653# a_527_591# 1.65e-20
C3082 a_5311_3855# a_1823_4943# 0.002934f
C3083 a_5689_4943# a_1692_4399# 1.04e-20
C3084 a_5356_2223# a_3847_3855# 2.96e-19
C3085 a_4180_6031# a_3905_5719# 8.47e-20
C3086 a_6219_4943# a_6412_4007# 1.25e-20
C3087 a_4252_6031# a_2283_5487# 8.68e-20
C3088 a_4621_6031# a_2235_5608# 1.02e-19
C3089 a_4931_2589# a_5188_2223# 0.024952f
C3090 a0 a_4728_4399# 0.058282f
C3091 a_4860_1367# a_443_591# 0.190224f
C3092 a_317_743# a_485_749# 0.565519f
C3093 b3 a_3799_4118# 0.032069f
C3094 a_4379_3677# a_3072_4399# 8.26e-21
C3095 a_947_4520# a_2327_4520# 0.004148f
C3096 a_4751_1831# a_4877_1679# 3.21e-20
C3097 a_1697_743# a_4709_1679# 2.1e-19
C3098 a_4847_1653# a_4793_1679# 0.009641f
C3099 a_395_2344# a_355_1653# 0.221088f
C3100 a_2045_2223# a_2249_3543# 8.84e-19
C3101 a_1037_4625# a_2249_3543# 0.00106f
C3102 a_297_3017# a_1037_4625# 2.96e-19
C3103 b1 a_2688_4221# 2.16e-19
C3104 a_395_2344# a_947_4520# 3.13e-20
C3105 a_5923_2223# a_2341_2455# 1.77e-19
C3106 a_984_6183# b1 0.065624f
C3107 a_481_6281# DVDD 0.772524f
C3108 a_1125_3017# a_317_743# 4.56e-21
C3109 a_5188_2223# a_5545_2925# 4.26e-19
C3110 a_5023_957# a_3663_1135# 0.001909f
C3111 a_2375_4399# a_5545_2925# 9.99e-19
C3112 a2 a_5192_4943# 3.42e-19
C3113 a_3609_4399# a_2341_2455# 1.46e-20
C3114 b2 a_2244_2767# 0.017926f
C3115 a0 a_3072_3311# 3.98e-20
C3116 b3 a_1865_749# 1.81e-21
C3117 b2 a_1733_5309# 4.34e-20
C3118 b3 a_1823_3855# 5.37e-20
C3119 a_849_3855# a_849_4105# 0.009512f
C3120 a0 a_2263_4943# 0.003799f
C3121 a_5023_591# a_443_591# 0.005119f
C3122 a_1125_3855# a_573_4105# 9.15e-21
C3123 a_2688_4943# a_2327_4520# 2.46e-19
C3124 a_5095_1929# a_5177_1929# 0.006406f
C3125 a_4625_749# a_4709_1929# 0.245113f
C3126 a_2235_1256# a_1775_854# 0.892218f
C3127 a_4751_1831# a_2467_2223# 2.08e-20
C3128 a_5188_2223# a_5923_1135# 3.64e-21
C3129 a_317_2455# a_1604_1501# 4.29e-20
C3130 a_3827_1679# a_4180_1679# 2.18e-19
C3131 a_1692_4399# a_4351_5206# 2.7e-20
C3132 a_1697_743# a_3537_1367# 0.255634f
C3133 a_3523_3030# a_1125_3017# 1.89e-19
C3134 a_883_2223# a_961_1831# 3.6e-19
C3135 a_4636_3311# a_5503_2767# 2.92e-19
C3136 b3 a4 0.189858f
C3137 a1 a_4544_3855# 5.55e-19
C3138 a_3387_6031# a_3471_6397# 0.030161f
C3139 a0 a_5575_6031# 2.12e-20
C3140 a_5095_1929# a_3847_3855# 3.78e-20
C3141 a_2235_1256# a_573_4105# 5.74e-21
C3142 a_4535_854# a_2244_2767# 1.04e-20
C3143 a_485_749# a_2367_1501# 2.26e-20
C3144 a_3523_3030# b5 3.51e-19
C3145 a_2520_3855# a_443_591# 2.86e-19
C3146 a_883_957# a_1236_957# 2.18e-19
C3147 a_297_3017# a_1400_3677# 6.11e-20
C3148 a_4728_4399# a_4824_4399# 0.004993f
C3149 a_995_4399# a_4399_4943# 9.87e-21
C3150 a_1692_4399# a_1907_5309# 3.55e-20
C3151 a_2263_6575# a_2520_6575# 0.024123f
C3152 a_1865_4013# a_5075_1148# 0.005723f
C3153 a4 a_1328_3311# 1.62e-19
C3154 a_259_1831# a_527_2223# 6.29e-19
C3155 a_6368_3133# a_4535_854# 3.4e-19
C3156 a_2263_6575# a_1823_6575# 0.006485f
C3157 a_2235_1256# a_1039_1942# 4.78e-19
C3158 a_3847_3855# a_4667_957# 3.41e-21
C3159 b3 a_1527_2045# 2.13e-19
C3160 P7 a_1865_749# 0.042067f
C3161 a_4436_2767# a_3847_3855# 1.74e-19
C3162 a_849_3017# a_2412_3133# 2.96e-19
C3163 a_4575_2223# a_4533_2449# 0.089278f
C3164 a_1865_4013# a_1508_1135# 0.503004f
C3165 a_3847_3855# a_4471_4399# 1.31e-19
C3166 b2 a_627_5487# 0.00542f
C3167 a_409_3543# a_297_4105# 0.002158f
C3168 a5 a_3517_5487# 1.46e-21
C3169 DVDD a_317_743# 0.702996f
C3170 a_5376_591# a_1865_749# 2.93e-20
C3171 a_3523_3030# a_4268_2767# 0.080698f
C3172 a_3813_3543# a_4364_3133# 1.44e-19
C3173 a_6005_2223# a_3891_3432# 2.87e-19
C3174 a_1497_6189# a_1907_6575# 8.61e-19
C3175 a_3164_2223# a_1823_4943# 8.31e-20
C3176 a_501_5719# a_2248_6397# 0.004869f
C3177 a_1895_6397# a_2320_6397# 1.31e-19
C3178 a_2459_3677# a_1823_4943# 4.45e-20
C3179 a_1037_4625# a_1733_4221# 3.66e-20
C3180 a_3072_4399# a_2283_5487# 0.463987f
C3181 a_4399_4943# a_2235_5608# 2.08e-19
C3182 a_1455_6031# b2 0.04164f
C3183 a_1497_6189# a_501_5719# 0.083256f
C3184 a_259_1831# a_1697_743# 2.02e-20
C3185 a_5081_2767# a4 1.86e-19
C3186 a_1455_6031# a_1895_6397# 0.038418f
C3187 a_2263_4221# a_2688_4221# 1.31e-19
C3188 a_2520_3855# a_2616_4221# 0.004869f
C3189 a0 a_1895_6031# 0.005487f
C3190 a_849_3017# a_409_3543# 0.008488f
C3191 b1 a_4483_5309# 0.024327f
C3192 a_1631_2767# a_1987_2767# 0.008475f
C3193 a_6047_2045# a_3663_1135# 0.001637f
C3194 b1 b3 0.104671f
C3195 DVDD P1 0.2907f
C3196 b0 P2 8.31e-20
C3197 DVDD a_3523_3030# 1.15562f
C3198 b3 a_3931_4221# 5.96e-20
C3199 a5 a_3799_4118# 0.002058f
C3200 a0 a_3891_3432# 6.33e-20
C3201 a_3983_5608# a_4824_5853# 7.33e-20
C3202 P6 a_4073_4625# 1.96e-19
C3203 a_6173_2223# a_5779_4943# 0.006728f
C3204 b1 a_1328_3311# 4.72e-20
C3205 a0 a_975_3311# 3.26e-20
C3206 a_984_6183# a_711_5853# 0.001415f
C3207 a_4709_1929# a_5223_1501# 4.87e-19
C3208 a_4575_2589# a_4751_1831# 1.77e-19
C3209 b4 a_4839_4943# 0.004592f
C3210 a5 a_1865_749# 3.12e-19
C3211 DVDD a_2367_1501# 0.034638f
C3212 a_2980_5487# a_1692_4399# 8.29e-21
C3213 a5 a_1823_3855# 0.048292f
C3214 a_5095_1929# a_4544_3855# 1.4e-20
C3215 a_2341_2455# a_2263_3855# 1.41e-22
C3216 a_3261_6183# a_2235_5608# 0.001914f
C3217 a_4625_749# a_3891_3432# 2.53e-19
C3218 a_4535_854# a_5943_2767# 2.66e-20
C3219 a2 a_3537_6807# 2.34e-21
C3220 a_395_854# a_1251_1135# 6.73e-19
C3221 a_5575_6397# a_6000_6397# 1.31e-19
C3222 a_485_749# a_895_1135# 2.61e-19
C3223 P5 a_1823_6575# 0.054221f
C3224 b2 a_1125_3017# 0.18526f
C3225 a_2244_2767# a_2459_4399# 2.15e-20
C3226 a_4751_1831# a_2341_2455# 0.002213f
C3227 DVDD a_883_5309# 0.266973f
C3228 a_501_5719# a3 2.29e-21
C3229 a_2325_5713# a_2327_4520# 0.006052f
C3230 a_2248_6397# a2 1.62e-19
C3231 a5 a_4023_3311# 0.001366f
C3232 a5 a4 0.809889f
C3233 b2 b5 0.034149f
C3234 a_4943_1653# a_4709_1929# 0.135024f
C3235 a1 P0 1.12e-19
C3236 a_757_6281# a_961_1831# 1.63e-20
C3237 a_1880_1679# a_317_743# 4.83e-20
C3238 a_4709_1929# a_5319_1174# 0.005265f
C3239 a_5135_6031# a_6000_6031# 8.47e-20
C3240 a_1497_6189# a2 0.008176f
C3241 a_2249_3543# a_1775_4118# 0.031964f
C3242 a_5448_591# DVDD 2.5e-20
C3243 a_5943_3133# a_6296_3133# 2.18e-19
C3244 a_297_3017# a_1775_4118# 1.71e-20
C3245 a_1697_743# a_5075_1148# 0.005666f
C3246 a_4751_1831# a_2980_1135# 0.118137f
C3247 a_5095_1929# a_443_591# 0.001088f
C3248 a_4847_1653# a_5289_1433# 1.39e-19
C3249 a_2815_4399# a_3240_4399# 1.31e-19
C3250 a_4625_749# a_4860_1367# 1.42e-19
C3251 a_2616_3855# a_1775_4118# 7.33e-20
C3252 a_2688_3855# a_1508_1135# 3.22e-19
C3253 a_2341_2455# a_4399_4943# 1.49e-21
C3254 a_4457_743# a_1865_749# 0.690873f
C3255 a_317_2455# a_1421_2919# 7.34e-19
C3256 a_1784_1679# a_1907_957# 3.59e-19
C3257 b3 a_527_2589# 0.004369f
C3258 b0 a_4073_4625# 0.051917f
C3259 a_3827_6031# a_4252_6031# 8.12e-20
C3260 a_2375_3311# a_3799_4118# 3.09e-19
C3261 a_3523_3030# a_3983_4520# 1.25e-19
C3262 a_3813_3543# a_4073_4625# 0.004046f
C3263 a_4636_3311# a_3609_4399# 1.02e-19
C3264 a_1329_6183# a_2263_5309# 1.11e-20
C3265 b5 a_4535_854# 0.069775f
C3266 a_248_4631# a_443_4943# 9.92e-19
C3267 a_1697_743# a_1508_1135# 0.001799f
C3268 a_3260_2223# a_3164_2223# 0.005002f
C3269 a3 a_1860_4765# 2.48e-19
C3270 a_2815_4765# a_2283_5487# 2.21e-20
C3271 a_5928_6397# a_2520_6575# 1.3e-19
C3272 b2 a_4268_2767# 0.005626f
C3273 a_3571_2767# a_395_854# 0.001878f
C3274 a_1823_6575# a_1236_5309# 2.4e-20
C3275 a_5023_591# a_4625_749# 0.045338f
C3276 a_2907_2589# a_2520_3855# 0.001469f
C3277 a_3747_6941# a_1775_6696# 0.065041f
C3278 a_5923_1135# a_6403_2045# 1.22e-19
C3279 a_619_3677# a_573_4105# 0.009481f
C3280 a_4457_743# a4 0.003336f
C3281 b0 a_1865_4013# 1.72e-20
C3282 a_469_1679# a_317_2455# 0.001134f
C3283 a_995_4399# a_4351_5206# 3.21e-21
C3284 b1 a_1420_5487# 1.62e-19
C3285 a_1733_6575# DVDD 4.94e-19
C3286 a_685_1367# a_1308_957# 9.69e-20
C3287 a_849_3017# a_1631_3133# 0.020012f
C3288 a_3471_6397# a_3517_5487# 0.007099f
C3289 a_4115_4765# a_4471_4765# 0.008475f
C3290 a_2327_3432# a_3072_3311# 0.078622f
C3291 a_2375_3311# a_1823_3855# 0.021084f
C3292 a_3813_3543# a_1865_4013# 0.245728f
C3293 a_1308_4943# P1 0.00792f
C3294 b1 a_1420_5853# 1.94e-19
C3295 a2 a_5503_2767# 0.018749f
C3296 a_5837_1831# a_6047_1679# 0.04028f
C3297 a_4533_2449# a_3663_1135# 4.18e-20
C3298 a_3387_6031# a_3983_5608# 0.092742f
C3299 a_1455_6031# a_5219_6397# 1.57e-20
C3300 a5 a_1539_6031# 4.59e-21
C3301 a2 a3 0.027238f
C3302 a_1895_6397# DVDD 0.144605f
C3303 a0 a1 0.291183f
C3304 b0 P3 0.01205f
C3305 a_4535_854# a_4268_2767# 0.026408f
C3306 DVDD b2 2.60566f
C3307 a2 a_6412_5719# 0.006004f
C3308 b1 a5 0.123812f
C3309 a_1775_854# a_2244_2767# 0.157394f
C3310 a_3813_3543# a_3849_3311# 2.48e-20
C3311 a_3523_3030# a_3240_3311# 2.88e-20
C3312 a_2375_3311# a_4023_3311# 2.61e-19
C3313 a_2375_3311# a4 0.017485f
C3314 P9 a_685_1367# 9.68e-19
C3315 DVDD a_895_1135# 0.252979f
C3316 a5 a_3241_3855# 1.62e-19
C3317 a_2263_6941# a_2616_6941# 2.18e-19
C3318 a_1329_6183# a_2157_5719# 8.23e-19
C3319 a_2249_4631# a_1823_4943# 0.058704f
C3320 a1 a_2723_5487# 1.03e-19
C3321 a_2244_2767# a_573_4105# 0.054431f
C3322 a_2263_591# a_443_591# 3.78e-19
C3323 a_627_5487# a_1907_6941# 0.035705f
C3324 a_1823_6575# a_2520_6575# 0.044649f
C3325 a_4115_5853# a_3905_5719# 0.041843f
C3326 a_4351_5206# a_2235_5608# 0.063872f
C3327 a_4471_5853# a_2283_5487# 3.21e-20
C3328 a_3941_5853# a_4031_5487# 0.006958f
C3329 DVDD a_4535_854# 1.99888f
C3330 a_5837_1831# a_5413_2767# 2.93e-20
C3331 a_353_591# a_317_743# 4.78e-19
C3332 a_1037_4625# a_409_3543# 0.001079f
C3333 a_5023_957# a_1865_749# 0.004066f
C3334 a_4456_6941# a_3517_5487# 0.001071f
C3335 a_4533_2449# a_6368_2767# 2.72e-21
C3336 a_1907_4221# a_1508_1135# 0.011205f
C3337 b3 a_3941_4765# 3.43e-19
C3338 a_1421_2919# a_1457_2767# 4.78e-19
C3339 b4 a_2520_6575# 3.39e-20
C3340 a_1907_3855# a_573_4105# 2.27e-20
C3341 a_961_1831# a_1251_1501# 1.54e-19
C3342 a_1039_1942# a_2244_2767# 0.049281f
C3343 DVDD a_2377_2223# 4.94e-19
C3344 a_3387_6031# a_1329_6183# 1.46e-19
C3345 a5 a_5779_4943# 1.88e-19
C3346 a_4401_2223# a_2341_2455# 3.02e-20
C3347 a_4943_1653# a_3891_3432# 0.001124f
C3348 a_3297_6031# a_2283_5487# 1.99e-19
C3349 P6 a_5821_5101# 7.09e-19
C3350 a1 a_4824_4399# 9.58e-20
C3351 a_5943_3133# a_5503_2767# 0.003925f
C3352 a_259_1831# a_895_1501# 0.073399f
C3353 a_6092_4221# a_4031_5487# 1.9e-19
C3354 b0 a_1365_6031# 7.33e-21
C3355 a0 a_2417_4625# 0.017491f
C3356 a_1400_3677# a_409_3543# 7.66e-19
C3357 a_2551_2589# a_2907_2589# 0.008475f
C3358 b3 a_2327_4520# 0.029636f
C3359 a_5667_3855# a_4031_5487# 0.005557f
C3360 b1 a_2375_3311# 4.4e-19
C3361 a5 a_527_2589# 0.003614f
C3362 a3 a_1236_2589# 1.05e-19
C3363 b5 a_5137_3855# 7.69e-20
C3364 a2 a_4824_5487# 3.94e-20
C3365 b2 a_3983_4520# 1.41e-20
C3366 a_395_2344# b3 0.056512f
C3367 a_2375_3311# a_3931_4221# 3.87e-21
C3368 a_3523_3030# a_2249_3543# 8.3e-19
C3369 a_4943_1653# a_4860_1367# 6.33e-19
C3370 a_2417_4625# a_2723_5487# 1.67e-20
C3371 a_5264_5309# a_4351_5206# 2.43e-19
C3372 a_1775_854# a_1676_1135# 7.42e-20
C3373 a_2327_3432# a_3891_3432# 0.003191f
C3374 a_2244_2767# a_1125_2767# 8.38e-21
C3375 a_5319_1174# a_4860_1367# 6.64e-19
C3376 b5 a_4379_3677# 1.45e-20
C3377 a_2467_2223# a_3747_1501# 4.78e-19
C3378 a_4457_743# a_5779_4943# 0.050229f
C3379 a_395_2344# a_1328_3311# 2.5e-20
C3380 a_3813_3543# a_1697_743# 2.85e-22
C3381 a_2520_6575# a_4031_5487# 4.14e-20
C3382 a_2367_5487# a_2723_5487# 0.009846f
C3383 a3 a_2263_6941# 4.67e-20
C3384 a_1171_2045# a_685_1367# 0.007993f
C3385 a_4528_6941# P3 0.00792f
C3386 a5 a_711_5487# 3.93e-20
C3387 a1 a_1067_5487# 4.74e-19
C3388 a_3537_1367# a_4456_1501# 0.001046f
C3389 a_2340_2767# a_1987_2767# 2.18e-19
C3390 a_2341_2455# a_4351_5206# 1.88e-21
C3391 P9 a_1236_591# 0.005587f
C3392 a_5023_591# a_4943_1653# 3.51e-20
C3393 a_627_5487# a_2283_5487# 1.62e-19
C3394 a_3537_6807# a_3905_5719# 0.001405f
C3395 a_2249_4631# a_2459_4765# 0.041751f
C3396 a_2375_4399# a_2285_4765# 0.006958f
C3397 a5 a_711_5853# 3.51e-19
C3398 a1 a_1067_5853# 2.03e-19
C3399 a_4073_4625# a_1692_4399# 0.537162f
C3400 a_3261_6183# a_3471_6031# 0.04028f
C3401 b4 a_3571_2767# 0.009529f
C3402 DVDD a_5376_957# 2.76e-19
C3403 b0 a_5821_5101# 0.060931f
C3404 a_1775_854# a_485_749# 0.13479f
C3405 a_5345_1929# a_3847_3855# 7.38e-19
C3406 b4 a_4031_5487# 0.109441f
C3407 a_757_6031# a_443_4943# 4.46e-20
C3408 a_4483_4943# a_3609_4399# 1.24e-19
C3409 b2 a_3240_3311# 1.55e-19
C3410 a_5095_1929# a_4625_749# 0.011973f
C3411 DVDD a_5219_6397# 0.252785f
C3412 a_4636_3311# a_4399_4943# 3.28e-21
C3413 a_757_6281# P0 3.31e-19
C3414 a_2235_1256# a_3076_1501# 7.33e-20
C3415 a_4268_2767# a_4379_3677# 1.38e-20
C3416 a_1455_6031# a_2283_5487# 0.0029f
C3417 a_1171_1679# a_395_854# 8.53e-21
C3418 a_2980_5487# a_2235_5608# 0.135627f
C3419 DVDD a_5667_4221# 0.1561f
C3420 a_527_2223# a_685_1367# 4.93e-19
C3421 DVDD a_2459_4399# 0.162119f
C3422 DVDD a_5587_3133# 0.149763f
C3423 a_1775_854# a_1125_3017# 0.003501f
C3424 a_2907_2223# a_849_4105# 3.33e-21
C3425 a_3537_1367# a_4528_1135# 6.73e-20
C3426 a_1865_4013# a_1692_4399# 0.00429f
C3427 a_3847_3855# a_5227_3855# 0.003739f
C3428 b5 a_1775_854# 4.41e-19
C3429 a2 a_3609_4399# 0.206111f
C3430 a_4625_749# a_4667_957# 0.089602f
C3431 a_961_1831# a_355_1653# 4.55e-19
C3432 P5 a_2375_4399# 0.002879f
C3433 a_961_1831# a_947_4520# 8.24e-20
C3434 a_1125_3017# a_573_4105# 0.626812f
C3435 DVDD a_4379_3677# 0.046154f
C3436 a_1508_1135# a_895_1501# 3.09e-19
C3437 b4 a_3655_3133# 0.004615f
C3438 a_2520_6575# a_6219_5309# 9.17e-20
C3439 b0 a_1907_4221# 8.07e-21
C3440 a_1039_1942# a_485_749# 2.8e-20
C3441 a_3747_6575# b0 0.002673f
C3442 a_849_3017# a_1823_3855# 0.007864f
C3443 a4 a_297_4105# 0.001323f
C3444 a_2412_3133# a_1775_4118# 1.64e-19
C3445 b5 a_573_4105# 0.069328f
C3446 a_2327_3432# a_2520_3855# 0.217462f
C3447 a_3983_5608# a_3517_5487# 0.00123f
C3448 a_1697_743# a_685_1367# 0.0017f
C3449 DVDD a_1907_6941# 0.001411f
C3450 a_1775_4118# a_2263_5309# 1.46e-19
C3451 a_259_1831# a_317_2455# 0.159711f
C3452 a_2325_5713# a_1775_6696# 8.45e-19
C3453 a_2263_4943# a_443_4943# 3e-21
C3454 a_1039_1942# a_1125_3017# 0.06909f
C3455 a_3164_2223# a_5503_2767# 1.09e-19
C3456 a_1775_854# a_4268_2767# 0.718997f
C3457 b5 a_1039_1942# 5.38e-21
C3458 a4 a_849_3017# 0.223897f
C3459 a_4471_4399# a_4824_4399# 2.18e-19
C3460 a_5009_6183# a_4839_5309# 0.023167f
C3461 a3 a_3905_5719# 2.05e-19
C3462 a_1365_6397# b1 4.48e-20
C3463 a_757_6281# a0 0.247869f
C3464 a5 a_2327_4520# 7.34e-20
C3465 b5 a_2283_5487# 2.74e-20
C3466 a_975_3677# a_1400_3677# 8.12e-20
C3467 a5 a_395_2344# 0.090894f
C3468 b2 a_2249_3543# 0.034225f
C3469 a1 a_2327_3432# 4.84e-20
C3470 b2 a_297_3017# 0.002678f
C3471 a_4457_743# a_5284_2223# 2.74e-19
C3472 a_4943_1653# a_5356_2223# 3.71e-19
C3473 b4 a_4471_5487# 0.006638f
C3474 a_3983_5608# a_3799_4118# 1.72e-19
C3475 a_481_6281# a_2263_5309# 3.93e-20
C3476 DVDD a_1775_854# 1.58344f
C3477 a_5837_1831# a_5188_2223# 0.020814f
C3478 a_2375_4399# a_6092_4221# 5.08e-19
C3479 a_4073_4625# a_5311_4221# 0.007941f
C3480 a_1527_2045# a_849_3017# 2.56e-20
C3481 a_1784_1679# a_1421_2919# 7.25e-21
C3482 a_4533_2449# a_3799_4118# 1.06e-21
C3483 a_2375_4399# a_3168_4399# 4.35e-21
C3484 a_1697_743# a_2263_957# 0.019831f
C3485 a_5413_3133# a_4073_4625# 3.78e-21
C3486 a_961_1831# a_1952_2045# 6.73e-20
C3487 a_5345_1929# a_4544_3855# 4.11e-20
C3488 a_5289_1433# a_3663_1135# 0.011725f
C3489 b2 a_4847_1653# 7.99e-22
C3490 a_2375_4399# a_5667_3855# 0.045338f
C3491 a_3799_4118# a_4640_3855# 7.33e-20
C3492 a_3164_2223# a_4011_3133# 0.011819f
C3493 a_1125_3017# a_1125_2767# 0.009374f
C3494 a_3571_2767# a_3655_3133# 0.030161f
C3495 b0 a_6219_4943# 7.99e-19
C3496 DVDD a_573_4105# 0.847074f
C3497 b1 a_297_4105# 1.06e-19
C3498 a_5943_2767# a_5545_2925# 0.045338f
C3499 a_3757_4221# a_1692_4399# 3.39e-20
C3500 a4 a_849_2767# 6e-19
C3501 a_4575_2223# a_3523_3030# 1.45e-20
C3502 a_1775_4118# a_3663_1135# 0.004383f
C3503 a_4533_2449# a_1865_749# 4.69e-22
C3504 a_4544_3855# a_5227_3855# 0.862267f
C3505 a_4640_4221# a_3847_3855# 4.35e-21
C3506 a_4712_4221# a_3072_3311# 1.05e-19
C3507 a_3983_4520# a_4379_3677# 3.7e-20
C3508 a_1784_1679# a_469_1679# 5.23e-20
C3509 a_3891_3432# a_6412_4007# 0.037331f
C3510 a_3931_3855# a_3847_3855# 0.061567f
C3511 a_4712_3855# a_1865_4013# 4.37e-20
C3512 a_4287_3855# a_3072_3311# 0.044609f
C3513 a_4847_1653# a_4535_854# 0.021211f
C3514 a_5863_5309# a_6412_5719# 3.02e-19
C3515 a_355_1653# a_443_591# 2.39e-19
C3516 a_6644_5309# a_2283_5487# 1.93e-21
C3517 a_527_4943# a_443_4943# 0.069376f
C3518 a_6219_5309# a_4031_5487# 1.72e-19
C3519 b1 a_849_3017# 4.22e-20
C3520 DVDD a_1039_1942# 0.807024f
C3521 a_4931_2589# b5 2.22e-19
C3522 a_1775_4118# a_2367_1135# 0.030246f
C3523 a_763_1256# a_2243_1929# 7.28e-19
C3524 a_1236_2223# a_395_2344# 4.95e-20
C3525 DVDD a_2283_5487# 1.17774f
C3526 a_4804_3311# a_4544_3855# 2.4e-19
C3527 a_2375_4399# a_1823_6575# 0.001346f
C3528 a_3240_3677# a_3072_3311# 0.008437f
C3529 a_4533_2449# a4 0.020852f
C3530 a_4023_3677# a_1865_4013# 6.88e-19
C3531 a_481_6281# a_2157_5719# 2.11e-19
C3532 a_5188_2223# a_6047_1679# 1.59e-19
C3533 a_6047_2045# a_5779_4943# 0.046674f
C3534 a_2907_2223# a_2235_1256# 1.97e-21
C3535 a_4943_1653# a_5095_1929# 0.063393f
C3536 a_2327_3432# a_2417_4625# 5.28e-20
C3537 a_2375_3311# a_2327_4520# 5.4e-20
C3538 a_4471_5487# a_4031_5487# 0.003858f
C3539 a_2551_2589# a_2327_3432# 2.68e-20
C3540 a_2235_1256# a_395_854# 7.05e-19
C3541 a_317_2455# a_1508_1135# 0.002286f
C3542 b5 a_849_3855# 8.33e-20
C3543 a_4709_1929# a_4709_1679# 7.04e-19
C3544 b4 a_2375_4399# 0.096273f
C3545 a_2263_6575# a_2688_6575# 1.31e-19
C3546 a2 a_2263_3855# 7.58e-21
C3547 a_4535_854# a_5653_5095# 5.94e-20
C3548 a_1823_6575# a_849_4105# 4.72e-21
C3549 a_248_4631# a_1508_1135# 4.6e-19
C3550 b5 a_5545_2925# 0.112028f
C3551 a_1692_4399# a_5821_5101# 0.001203f
C3552 a_2459_4765# a_1823_4943# 0.007642f
C3553 a_1907_4943# a_1329_6183# 6.15e-21
C3554 a_4636_3311# a_4351_5206# 2.32e-20
C3555 b4 a_849_4105# 7.88e-19
C3556 a2 a_4751_1831# 1.68e-21
C3557 a_3387_6031# a_481_6281# 1.03e-19
C3558 a_501_5719# a_3261_6183# 9.82e-20
C3559 a_4931_2589# a_4268_2767# 0.044609f
C3560 a_4839_4943# a_3072_4399# 0.044609f
C3561 a_3847_3855# a_4252_1679# 3.74e-20
C3562 a_4483_4943# a_4399_4943# 0.098235f
C3563 a_1865_4013# a_4877_1679# 7.86e-19
C3564 b3 a_1631_2767# 3.08e-19
C3565 a_995_4399# a_4073_4625# 0.010824f
C3566 a_757_6281# a_1067_5487# 0.00831f
C3567 a_4103_6941# a1 8.67e-20
C3568 a_3537_1367# a_4709_1929# 0.009743f
C3569 a_1631_3133# a_1775_4118# 2.91e-20
C3570 a_757_6281# a_1067_5853# 0.004956f
C3571 a_353_5309# a_443_4943# 0.006823f
C3572 a_2045_2223# a_1865_749# 1.54e-21
C3573 a_317_2455# a_527_957# 2.72e-19
C3574 a_627_5487# a_3827_6031# 1.08e-19
C3575 a2 a_4399_4943# 0.04753f
C3576 a_3537_6807# a_4180_6031# 0.005368f
C3577 b3 a_1775_6696# 9.05e-20
C3578 a_2467_2223# a_1865_4013# 1.17e-19
C3579 a_2045_2223# a_1823_3855# 0.041708f
C3580 b1 a_3983_5608# 0.015154f
C3581 P5 a_3072_4399# 3.06e-20
C3582 DVDD a_5689_5309# 4.94e-19
C3583 a_1037_4625# a_1823_3855# 0.02606f
C3584 DVDD a_4931_2589# 8.16e-19
C3585 a_995_4399# a_1865_4013# 0.345143f
C3586 a_1907_4221# a_1692_4399# 9.52e-20
C3587 a_4252_2045# a_1865_4013# 3.14e-20
C3588 a_1733_4943# a_995_4399# 2.46e-19
C3589 a_3813_3543# a_4011_2767# 1.48e-20
C3590 b1 a_5137_4221# 2.63e-21
C3591 a_3523_3030# a_3655_2767# 0.017809f
C3592 a_5188_2223# a_3571_2767# 3.26e-21
C3593 P1 a_409_3543# 8.5e-21
C3594 a_4287_4221# a_4712_4221# 1.31e-19
C3595 a_4544_3855# a_4640_4221# 0.004869f
C3596 a_2980_5487# a_3471_6031# 0.024023f
C3597 a_3609_4399# a_3164_2223# 5.09e-21
C3598 a_1455_6031# a_3827_6031# 0.045338f
C3599 a_5188_2223# a_4031_5487# 1.26e-19
C3600 a_2249_3543# a_2459_4399# 6.48e-21
C3601 DVDD a_3941_5487# 5.76e-19
C3602 a_1880_1679# a_1039_1942# 7.33e-20
C3603 a4 a_2045_2223# 0.141383f
C3604 a_2249_4631# a_6412_5719# 1.33e-20
C3605 a_2375_4399# a_4031_5487# 0.739841f
C3606 a3 a_2249_4631# 0.016898f
C3607 a_3609_4399# a_3905_5719# 0.002302f
C3608 a_4073_4625# a_2235_5608# 2.21e-20
C3609 a_3983_4520# a_2283_5487# 0.013099f
C3610 a_1497_6189# a_1435_4399# 3.77e-22
C3611 DVDD a_5545_2925# 1.05161f
C3612 a4 a_1037_4625# 0.003704f
C3613 P0 a_947_4520# 1.19e-19
C3614 a_3891_3432# a_4287_3855# 9.59e-19
C3615 a_3537_1367# a_4379_3311# 8e-20
C3616 a_317_743# a_3663_1135# 0.069299f
C3617 a_849_3017# a_2263_4221# 2.43e-21
C3618 a_1421_2919# a_2520_3855# 2.92e-20
C3619 a_2815_3677# a_849_4105# 0.045338f
C3620 b0 a_3573_6941# 2.72e-20
C3621 a1 a_6412_4007# 0.002421f
C3622 a_4728_4399# a_4896_4765# 0.00792f
C3623 a_3261_6183# a2 1.35e-19
C3624 DVDD a_5923_1135# 0.227421f
C3625 a_1539_6031# a_1329_6183# 0.041779f
C3626 a_1769_3631# a_1865_4013# 1.31e-20
C3627 b1 a_1329_6183# 0.289257f
C3628 a_1865_4013# a_2235_5608# 6.6e-20
C3629 a_317_743# a_2367_1135# 0.002493f
C3630 a_685_1367# a_895_1501# 0.04028f
C3631 a3 a_2723_5853# 6.82e-19
C3632 a_5575_6397# a_4399_4943# 2.44e-20
C3633 a_4943_1653# a_5002_1501# 4.99e-19
C3634 a_1784_1679# a_3537_1367# 0.023998f
C3635 a_2325_5713# a_2248_6031# 1.99e-20
C3636 a_353_4943# a_317_5095# 4.78e-19
C3637 a_3523_3030# a_3663_1135# 8e-20
C3638 a1 a_1421_2919# 3.14e-21
C3639 a_5667_4221# a_5653_5095# 0.029764f
C3640 a_3168_4399# a_3072_4399# 0.004987f
C3641 a_4533_2449# a_5779_4943# 0.025348f
C3642 a1 a_443_4943# 0.309543f
C3643 a_5009_6183# b0 0.086421f
C3644 a_6020_3855# a_1823_4943# 1.34e-19
C3645 a_5837_1831# a_6403_2045# 0.017321f
C3646 a_1400_3677# a4 6.36e-19
C3647 a_5137_3855# a_5653_5095# 5.48e-20
C3648 a_6173_2223# a_3847_3855# 1.69e-21
C3649 a_5045_6031# a_2235_5608# 1.25e-19
C3650 a_2907_2223# a_3332_2223# 1.31e-19
C3651 a_5356_2589# a_5188_2223# 0.008482f
C3652 a_1308_2223# a_317_2455# 3.01e-21
C3653 DVDD a_1435_4765# 8.16e-19
C3654 a_4839_4943# a_5264_4943# 8.12e-20
C3655 b1 a_2045_2223# 1.12e-21
C3656 a_4943_1653# a_5002_1174# 1.68e-19
C3657 b5 a_1079_4399# 0.002339f
C3658 a4 a_905_4399# 2.2e-21
C3659 a_1697_743# a_4877_1679# 8.44e-19
C3660 a_4751_1831# a_5873_1679# 1.32e-19
C3661 a0 a_947_4520# 0.11426f
C3662 a_4847_1653# a_5345_1679# 0.00273f
C3663 b0 a_248_4631# 0.420203f
C3664 b1 a_1037_4625# 0.040275f
C3665 a_1775_854# a_2249_3543# 2.63e-21
C3666 b4 a_2235_1256# 2.08e-20
C3667 a_995_4399# a_3757_4221# 7.36e-20
C3668 a5 a_1631_2767# 0.005457f
C3669 a_4103_6575# a_3983_5608# 2.23e-20
C3670 a_3609_4399# a_4115_5487# 8.63e-21
C3671 b2 a_2412_3133# 1.18e-19
C3672 a_2781_2767# a_2520_3855# 3.65e-19
C3673 a0 a_5227_3855# 7.21e-20
C3674 a_3537_1367# a_3891_3432# 1.39e-19
C3675 a_4575_2589# a_1865_4013# 0.00791f
C3676 a_4667_591# a_2980_1135# 0.036063f
C3677 b2 a_2263_5309# 0.017949f
C3678 b3 a_3847_3855# 0.001295f
C3679 a_297_3017# a_573_4105# 0.041383f
C3680 a_395_2344# a_297_4105# 0.002706f
C3681 a0 a_2688_4943# 2.06e-19
C3682 a_2249_3543# a_573_4105# 0.001052f
C3683 a_3241_4943# a_2417_4625# 1.08e-20
C3684 a_4625_749# a_5345_1929# 1.11e-19
C3685 a_4847_1653# a_1775_854# 0.278868f
C3686 a_6403_1679# a_1823_4943# 0.045338f
C3687 a_1697_743# a_2467_2223# 0.025923f
C3688 DVDD a_2367_5853# 0.001386f
C3689 a_2459_3311# a_849_4105# 0.133923f
C3690 a_5448_591# a_3663_1135# 8.47e-20
C3691 b4 a_3072_4399# 0.077614f
C3692 a_259_1831# a_1784_1679# 2.74e-19
C3693 a1 a_2689_6031# 2.39e-20
C3694 a_1697_743# a_4252_2045# 4.01e-20
C3695 P8 a_1823_4943# 0.001831f
C3696 a_1421_2919# a_2417_4625# 5.82e-21
C3697 a_4709_1929# a_5075_1148# 0.060844f
C3698 a_849_3017# a_2327_4520# 3.67e-21
C3699 a_2341_2455# a_1865_4013# 0.209332f
C3700 b2 a_409_3543# 0.039715f
C3701 a_4483_4943# a_4351_5206# 0.017871f
C3702 a_4401_2589# a4 2.09e-19
C3703 a_4180_6397# a_3905_5719# 4.54e-20
C3704 a_4252_6397# a_2283_5487# 2.61e-20
C3705 a_1039_1942# a_2249_3543# 8.78e-19
C3706 a_5095_1929# a_6412_4007# 8.69e-20
C3707 a_4625_749# a_5227_3855# 2.97e-19
C3708 a_395_2344# a_849_3017# 0.001852f
C3709 a_297_3017# a_1039_1942# 8.75e-19
C3710 a1 a_1788_4399# 6.24e-20
C3711 a_445_3677# b5 3.43e-20
C3712 a_961_1831# b3 0.051994f
C3713 a_3537_1367# a_4860_1367# 0.012126f
C3714 a_2285_3677# a_2249_3543# 4.78e-19
C3715 DVDD a_3827_6031# 9.53e-19
C3716 a_2688_6575# a_2520_6575# 0.007773f
C3717 a_1865_749# a_5289_1433# 7.66e-21
C3718 a_2493_1679# a_1775_4118# 3.43e-19
C3719 a_1865_4013# a_2980_1135# 3.84e-20
C3720 a_2815_3311# a_2459_3311# 0.009846f
C3721 a_3571_2767# a_3573_1501# 1.91e-19
C3722 DVDD a_1079_4399# 0.162179f
C3723 a2 a_4351_5206# 0.07925f
C3724 a_2244_2767# a_395_854# 6.72e-20
C3725 a_3517_5487# a_3517_5807# 0.009968f
C3726 a_3537_1367# a_3827_1679# 0.023959f
C3727 a_961_1831# a_1328_3311# 0.00503f
C3728 a_2235_1256# a_3571_2767# 0.035667f
C3729 b2 a_2157_5719# 0.080517f
C3730 a_3941_4399# a_1692_4399# 6.39e-20
C3731 a_355_1653# a_883_2589# 0.028709f
C3732 a_317_2455# a_685_1367# 0.142695f
C3733 a_1775_4118# a_1865_749# 0.001386f
C3734 a_3072_3311# a_1508_1135# 0.002749f
C3735 a_2375_4399# a_5188_2223# 5.48e-21
C3736 a_1823_3855# a_1775_4118# 0.514618f
C3737 a4 a_5289_1433# 1.83e-19
C3738 a_2249_4631# a_3609_4399# 0.017942f
C3739 a_3523_3030# a_4436_3133# 3.18e-19
C3740 a_1907_4943# a_1775_4118# 4.63e-20
C3741 a_2263_4943# a_1508_1135# 3.23e-21
C3742 a_2493_1929# a_2045_2223# 0.001445f
C3743 a_3297_6397# a1 1.97e-20
C3744 a_3571_2767# a_3072_4399# 9.87e-21
C3745 a_5503_2767# a_1823_4943# 0.283534f
C3746 a_2375_4399# a_849_4105# 2.85e-19
C3747 a_995_4399# a_1907_4221# 0.040473f
C3748 a_4399_4943# a_3905_5719# 0.027162f
C3749 a3 a_1823_4943# 0.470544f
C3750 a_3471_2045# a_3827_2045# 0.009846f
C3751 a_3072_4399# a_4031_5487# 5.81e-19
C3752 a_5653_5095# a_2283_5487# 1.05e-19
C3753 a_1823_4943# a_6412_5719# 0.00247f
C3754 a_2980_5487# a_501_5719# 3.33e-20
C3755 a_3387_6031# b2 1.4e-19
C3756 a_3537_1367# a_2520_3855# 1.24e-20
C3757 a4 a_1775_4118# 0.245629f
C3758 a_553_1679# a_1171_2045# 0.040213f
C3759 a2 a_5541_4719# 2.73e-20
C3760 a_947_4520# a_1067_5487# 5.28e-20
C3761 a_1251_1501# a_1604_1501# 2.18e-19
C3762 DVDD a_445_3677# 3.25e-19
C3763 a_4535_854# a_3663_1135# 0.044712f
C3764 a_947_4520# a_1067_5853# 2.1e-20
C3765 a1 a_905_4765# 2.39e-19
C3766 a5 a_573_4719# 3.15e-20
C3767 b3 a_3757_3855# 4.88e-21
C3768 a_1784_1679# a_1508_1135# 0.008217f
C3769 a_2723_5853# a_3148_5853# 8.12e-20
C3770 a_4575_2589# a_1697_743# 3.42e-20
C3771 a_5009_6183# a_1692_4399# 8.82e-20
C3772 a_763_1256# a_1604_1135# 4.95e-20
C3773 a5 a_3847_3855# 0.065254f
C3774 a_3261_6183# a_3905_5719# 0.001866f
C3775 a_2815_3311# a_849_4105# 0.124526f
C3776 a_1329_6183# a_2327_4520# 2.26e-20
C3777 a_975_3311# a_1400_3311# 1.31e-19
C3778 b2 a_1631_3133# 0.002896f
C3779 a_5837_1831# a_2244_2767# 0.001734f
C3780 a_4575_2223# a_1775_854# 0.030606f
C3781 a_1697_743# a_2341_2455# 0.17184f
C3782 a_4847_1653# a_5545_2925# 1.35e-20
C3783 a_5863_5309# a_4399_4943# 0.033026f
C3784 a_2325_5713# a0 0.001674f
C3785 a_248_4631# a_1692_4399# 1.04e-19
C3786 a_757_6031# b0 5.49e-19
C3787 a_4943_1653# a_5345_1929# 5.2e-20
C3788 a_757_6281# a_1421_2919# 1.7e-21
C3789 a_4457_743# a_5177_1929# 0.003313f
C3790 b1 a_1775_4118# 0.029162f
C3791 a5 a_961_1831# 0.03887f
C3792 b2 a_975_3677# 0.001248f
C3793 a_4709_1929# a_6173_1135# 1.09e-19
C3794 b1 a_4896_5487# 3.29e-19
C3795 a_2980_5487# a2 0.054147f
C3796 a_757_6281# a_443_4943# 0.083737f
C3797 a_553_1679# a_1697_743# 0.008111f
C3798 a_4544_3855# a_4896_4399# 4.71e-20
C3799 a_5837_1831# a_6368_3133# 0.007578f
C3800 a_4535_854# a_4456_1135# 6.26e-20
C3801 a_1697_743# a_2980_1135# 0.012317f
C3802 a_3537_6807# a_4115_5853# 0.001098f
C3803 a_3072_4399# a_4471_5487# 1.32e-19
C3804 a_2325_5713# a_2723_5487# 0.119653f
C3805 a_5545_2925# a_5653_5095# 6.18e-19
C3806 a_5667_3855# a_6092_3855# 8.12e-20
C3807 b0 a_4728_4399# 0.183992f
C3808 a_4943_1653# a_5227_3855# 6.9e-19
C3809 a_2341_2455# a_3297_1679# 1.41e-20
C3810 a_4457_743# a_3847_3855# 0.005299f
C3811 a_317_743# a_1865_749# 0.160948f
C3812 a_395_854# a_485_749# 1.0426f
C3813 a_4860_1367# a_5075_1148# 0.061523f
C3814 b4 a_4471_5853# 0.009042f
C3815 a_2377_2589# a_2045_2223# 1.73e-19
C3816 a_1823_3855# a_317_743# 9.95e-19
C3817 a_3813_3543# a_4728_4399# 2.87e-20
C3818 a_3523_3030# a_3799_4118# 0.001078f
C3819 a_4636_3311# a_4073_4625# 1.19e-19
C3820 a_1037_4625# a_2327_4520# 0.002326f
C3821 a3 a_763_1256# 0.00188f
C3822 a_2907_2223# a_1125_3017# 0.105446f
C3823 a3 a_2459_4765# 5.19e-19
C3824 a_395_2344# a_2045_2223# 3.92e-19
C3825 b2 a_4436_3133# 4.75e-20
C3826 a_481_6281# a_1539_6031# 0.017809f
C3827 a_481_6281# b1 0.439988f
C3828 a_984_6183# a0 0.01252f
C3829 a_5376_957# a_3663_1135# 5.56e-20
C3830 a_4456_6941# a_1775_6696# 9.03e-20
C3831 P7 a_443_591# 0.015969f
C3832 b4 a_2244_2767# 0.008971f
C3833 a_2249_4631# a_2263_3855# 7.97e-20
C3834 a_2157_5719# a_2459_4399# 2.27e-21
C3835 a_2263_6575# DVDD 0.155305f
C3836 a4 a_317_743# 2.07e-19
C3837 a_4471_4765# a_4824_4765# 2.18e-19
C3838 a_5376_591# a_443_591# 1.91e-19
C3839 a_5023_591# a_5075_1148# 8.66e-20
C3840 a_2375_3311# a_3847_3855# 0.025628f
C3841 a_3813_3543# a_3072_3311# 0.03915f
C3842 a_3523_3030# a_1823_3855# 2.11e-21
C3843 a_1125_3855# a_849_4105# 4.99e-19
C3844 a_4636_3311# a_1865_4013# 0.001916f
C3845 b1 a_1861_5807# 1.36e-19
C3846 a_763_1256# a_997_2045# 0.006823f
C3847 a_5837_1831# a_6756_1679# 2.54e-19
C3848 a_3387_6031# a_5219_6397# 0.024976f
C3849 a_5135_6031# a_3983_5608# 0.015496f
C3850 a_5095_1929# a_3537_1367# 1.99e-19
C3851 a_2235_1256# a_1171_1679# 5.11e-21
C3852 a_501_5719# P2 0.002304f
C3853 a_1527_2045# a_317_743# 3.36e-19
C3854 a5 a_4544_3855# 0.064966f
C3855 a5 a_2340_2767# 1.1e-20
C3856 P1 a4 8.07e-20
C3857 a_3523_3030# a_4023_3311# 0.033199f
C3858 a_2235_1256# a_849_4105# 2.28e-21
C3859 b0 a_5575_6031# 8.33e-19
C3860 a_3813_3543# a_4379_3311# 0.017619f
C3861 a_3523_3030# a4 0.018946f
C3862 a_2375_3311# a_961_1831# 9.18e-21
C3863 a_1823_3855# a_2367_1501# 0.001595f
C3864 a5 a_3757_3855# 2.77e-19
C3865 a_5923_2223# a_1823_4943# 4.61e-19
C3866 a_883_957# a_1308_957# 1.31e-19
C3867 P6 a_3891_3432# 0.012031f
C3868 a_2520_6575# a_2688_6941# 0.008182f
C3869 a_2249_4631# a_4399_4943# 0.024552f
C3870 a_4011_2767# a_2467_2223# 1.97e-21
C3871 a_3609_4399# a_1823_4943# 1.27e-19
C3872 a_5188_2223# a_6403_2045# 1.1e-19
C3873 a_2375_4399# a_3072_4399# 0.06892f
C3874 a_627_5487# a_2520_6575# 0.115079f
C3875 a0 a_4824_4765# 1.2e-19
C3876 a_5837_1831# a_5943_2767# 0.024292f
C3877 a_4471_5853# a_4031_5487# 0.041515f
C3878 a_4351_5206# a_3905_5719# 0.23924f
C3879 a_259_1831# a_883_2223# 2.79e-19
C3880 a_4896_5853# a_2235_5608# 1.71e-19
C3881 a_219_1929# a_527_2223# 0.001107f
C3882 a_2493_1929# a_1775_4118# 0.00185f
C3883 a_4436_2767# a_3537_1367# 2.13e-20
C3884 a_2520_3855# a_1508_1135# 0.132084f
C3885 a_3747_6941# a_4103_6941# 0.008475f
C3886 a_2263_4221# a_1775_4118# 0.015983f
C3887 b3 a_4471_4765# 3.08e-20
C3888 a_1823_6575# a_627_5487# 0.472101f
C3889 a_1421_2919# a_1987_2767# 0.044609f
C3890 a_849_3017# a_1631_2767# 0.017809f
C3891 a_849_4105# a_3072_4399# 1.58e-20
C3892 P9 a_883_957# 0.02283f
C3893 a_2325_5713# a_1067_5487# 8.7e-20
C3894 a_3571_2767# a_2244_2767# 0.033664f
C3895 DVDD a_2907_2223# 0.155265f
C3896 b4 a_627_5487# 0.001252f
C3897 a_409_3543# a_573_4105# 0.223748f
C3898 a_5345_1679# a_3663_1135# 1.35e-19
C3899 a_2320_6397# a_1823_6575# 4.29e-20
C3900 b2 a_3517_5487# 0.010641f
C3901 a_1455_6031# a_2520_6575# 5.46e-19
C3902 DVDD a_395_854# 1.77154f
C3903 a3 a_1987_3133# 4.58e-19
C3904 DVDD a_4839_4943# 8.16e-19
C3905 a_4457_743# a_4544_3855# 7.4e-19
C3906 a_2616_5309# a_2235_5608# 1e-19
C3907 a_1455_6031# a_1823_6575# 0.050364f
C3908 a_4931_2223# a_2341_2455# 0.001067f
C3909 a0 a_883_4943# 1.79e-19
C3910 b1 a_1236_4943# 1.53e-19
C3911 b0 a_527_4943# 0.005109f
C3912 a_6296_3133# a_5503_2767# 4.35e-21
C3913 a_3481_2767# a_3164_2223# 4.78e-19
C3914 a_1784_1679# a_2193_1501# 7.43e-19
C3915 a1 a_1508_1135# 1.09e-19
C3916 a_3261_6183# a_2249_4631# 1.93e-19
C3917 a_1455_6031# b4 1.5e-19
C3918 b0 a_1895_6031# 0.001134f
C3919 a0 a_4483_5309# 0.003115f
C3920 a3 a_1733_3855# 1.57e-19
C3921 a_1039_1942# a_409_3543# 0.001433f
C3922 a_1775_854# a_3663_1135# 0.004129f
C3923 a_5265_4719# a_4031_5487# 2.99e-20
C3924 a3 a_3240_4399# 3.48e-20
C3925 a_5837_1831# b5 4.44e-20
C3926 b1 P1 0.018955f
C3927 a0 b3 0.408031f
C3928 DVDD P5 0.230219f
C3929 a_2907_2589# a_3260_2589# 2.18e-19
C3930 a_2907_2589# b3 2.55e-20
C3931 a_6092_3855# a_4031_5487# 2.57e-20
C3932 b5 a_5667_3855# 8.59e-20
C3933 a_1251_1135# a_1676_1135# 1.31e-19
C3934 a_757_6281# a_905_4765# 2.4e-19
C3935 b2 a_3799_4118# 6.15e-20
C3936 a_984_6183# a_1067_5487# 0.02316f
C3937 a_3523_3030# a_3931_4221# 4.82e-20
C3938 b0 a_3891_3432# 7.81e-20
C3939 a_4457_743# a_443_591# 0.286928f
C3940 a_1775_854# a_2367_1135# 0.002382f
C3941 a_984_6183# a_1067_5853# 0.062535f
C3942 a_3813_3543# a_3891_3432# 0.855815f
C3943 b0 a_975_3311# 1.86e-19
C3944 b5 a_4804_3677# 7.9e-20
C3945 a_317_2455# a_2467_2223# 8.82e-20
C3946 a_2723_5487# a_3076_5487# 2.18e-19
C3947 a_4636_3311# a_1697_743# 1.18e-21
C3948 a_1784_1679# a_685_1367# 0.025028f
C3949 b2 a_1823_3855# 0.037486f
C3950 a_4351_5206# a_4115_5487# 0.003834f
C3951 a_2157_5719# a_2283_5487# 0.788922f
C3952 a_5837_1831# a_4268_2767# -3.39e-36
C3953 a_2327_3432# a_3168_3677# 7.33e-20
C3954 b2 a_1907_4943# 0.001617f
C3955 a3 a_3537_6807# 0.025352f
C3956 a_248_4631# a_995_4399# 0.00348f
C3957 a_627_5487# a_4031_5487# 7.09e-20
C3958 a_4728_4399# a_1692_4399# 0.052382f
C3959 a_2249_4631# a_3168_4765# 2.32e-19
C3960 b4 a_1125_3017# 0.094486f
C3961 a_2375_4399# a_2815_4765# 0.033195f
C3962 b5 a_1823_6575# 3.03e-20
C3963 a_3983_5608# a_1775_6696# 7.36e-19
C3964 a_763_1256# a_1527_1679# 0.03645f
C3965 P8 a_5503_2767# 9.98e-20
C3966 DVDD a_1236_5309# 5.13e-19
C3967 b1 a_883_5309# 1.04e-20
C3968 DVDD a_5928_6397# 2.76e-19
C3969 a_5345_1929# a_6412_4007# 1.1e-19
C3970 b2 a_4023_3311# 0.00504f
C3971 a1 P6 0.003678f
C3972 a_4309_4943# a_3799_4118# 1.5e-19
C3973 b2 a4 0.390511f
C3974 a_5264_4943# a_2375_4399# 1.62e-19
C3975 b4 b5 0.06547f
C3976 a_4483_4943# a_4073_4625# 3.42e-19
C3977 a5 P0 0.002732f
C3978 a_4839_4943# a_3983_4520# 6.73e-19
C3979 a_1775_4118# a_2327_4520# 0.004972f
C3980 a_1697_743# a_2723_1501# 0.003323f
C3981 a_1508_1135# a_2417_4625# 0.002142f
C3982 a_2244_2767# a_2459_3311# 3.08e-19
C3983 a_2377_2589# a_1775_4118# 2.22e-19
C3984 a_4535_854# a_1865_749# 0.138949f
C3985 a_1455_6031# a_4031_5487# 4.48e-19
C3986 a_2980_5487# a_3905_5719# 0.001909f
C3987 a_5009_6183# a_2235_5608# 0.005484f
C3988 a_3387_6031# a_2283_5487# 0.01305f
C3989 a_1497_6189# a3 3.28e-21
C3990 DVDD a_5837_1831# 1.2845f
C3991 a_3523_3030# a_3471_1679# 3.63e-22
C3992 DVDD a_6092_4221# 4.72e-19
C3993 a_395_2344# a_1775_4118# 2.78e-21
C3994 a_3164_2223# a_3747_1501# 3.46e-20
C3995 a_5095_1929# a_5075_1148# 0.001152f
C3996 DVDD a_3168_4399# 4.94e-19
C3997 a_3072_3311# a_1692_4399# 0.026463f
C3998 a4 a_895_1135# 3.84e-20
C3999 DVDD a_5667_3855# 8.16e-19
C4000 a_5587_2767# a_5503_2767# 0.066185f
C4001 a_5227_3855# a_6412_4007# 5.96e-19
C4002 a_355_1653# a_1421_2919# 2.62e-20
C4003 b3 a_883_2589# 0.040315f
C4004 a_1784_1679# a_2263_957# 5.72e-19
C4005 a_2377_2223# a_1823_3855# 4.48e-20
C4006 a_2551_2223# a_1865_4013# 3.56e-21
C4007 a_4011_2767# a_2341_2455# 0.002617f
C4008 a2 a_4073_4625# 0.028173f
C4009 a_947_4520# a_1421_2919# 2.53e-19
C4010 a_5943_2767# a_4031_5487# 2.43e-21
C4011 b2 a_1527_2045# 2.9e-20
C4012 P7 a_4625_749# 0.098962f
C4013 a4 a_4535_854# 0.066923f
C4014 a_947_4520# a_443_4943# 6.67e-19
C4015 a_1631_3133# a_573_4105# 0.113041f
C4016 a_4751_1831# a_1823_4943# 0.001691f
C4017 a_5023_957# a_443_591# 0.002135f
C4018 b4 a_4268_2767# 0.063102f
C4019 a_1329_6183# a_1775_6696# 0.008831f
C4020 a_4456_6575# b0 1.22e-19
C4021 a_2375_3311# a_3471_2045# 2.8e-20
C4022 a_1692_4399# a_5575_6031# 1.38e-20
C4023 a_961_1831# a_297_4105# 1.35e-20
C4024 DVDD a_2520_6575# 0.97931f
C4025 a2 a_1865_4013# 0.005029f
C4026 a_469_1679# a_355_1653# 0.001869f
C4027 a0 a_1420_5487# 1.28e-19
C4028 a_2249_4631# a_4351_5206# 0.002059f
C4029 a_1039_1942# a_1631_3133# 0.030177f
C4030 a_3571_2767# a_1125_3017# 0.004495f
C4031 DVDD a_1823_6575# 0.861286f
C4032 a0 a_1420_5853# 1.42e-19
C4033 a_2815_3677# a_1125_3017# 3.88e-21
C4034 a_1823_4943# a_4399_4943# 2.22e-19
C4035 DVDD a_6047_1679# 0.007454f
C4036 b2 a_1539_6031# 0.001089f
C4037 b5 a_3571_2767# 0.002953f
C4038 a_6756_2045# a_1823_4943# 1.59e-19
C4039 b1 b2 0.964965f
C4040 DVDD b4 1.22147f
C4041 a_501_5719# a_1365_6031# 8.64e-19
C4042 a_627_5487# a_4471_5487# 1.33e-20
C4043 b0 a1 0.74058f
C4044 a0 a5 0.00173f
C4045 b3 a_1907_957# 3.8e-22
C4046 a_5009_6183# a_5264_5309# 0.007718f
C4047 a_961_1831# a_849_3017# 0.028199f
C4048 a_1895_6397# b1 1.25e-20
C4049 a5 a_2907_2589# 1.2e-20
C4050 b5 a_4031_5487# 0.080033f
C4051 a1 a_3813_3543# 2.28e-20
C4052 a_5545_2925# a_3663_1135# 6.53e-19
C4053 a_4943_1653# a_6173_2223# 0.114973f
C4054 a_4457_743# a_6005_2223# 0.003966f
C4055 DVDD a_1251_1135# 0.237898f
C4056 a_2980_5487# a_4115_5487# 8.19e-20
C4057 a_1435_4765# a_409_3543# 6.48e-21
C4058 a_2244_2767# a_849_4105# 0.002881f
C4059 a_4073_4625# a_6020_4221# 1.53e-20
C4060 a_2616_591# a_443_591# 3.49e-20
C4061 a_2249_4631# a_5541_4719# 3.17e-19
C4062 a_2375_4399# a_5265_4719# 1.08e-19
C4063 a_5923_1135# a_3663_1135# 0.221141f
C4064 a_4533_2449# a_5177_1929# 0.001144f
C4065 a_5376_957# a_1865_749# 4.35e-21
C4066 a_4073_4625# a_5311_3855# 7.74e-19
C4067 a_527_591# a_317_743# 0.04028f
C4068 a_2375_4399# a_6092_3855# 3.17e-20
C4069 a_1125_3017# a_3655_3133# 4.54e-20
C4070 a_3571_2767# a_4268_2767# 0.049813f
C4071 P11 a_1697_743# 0.008448f
C4072 a_947_4520# a_1788_4399# 3.03e-19
C4073 a_1907_3855# a_849_4105# 0.035584f
C4074 a_317_2455# a_2341_2455# 0.002749f
C4075 a_4268_2767# a_4031_5487# 4.68e-20
C4076 a_4287_4221# a_1692_4399# 0.003852f
C4077 a_2688_591# a_1697_743# 3.22e-19
C4078 a_2723_1135# a_2980_1135# 0.024045f
C4079 a_961_1831# a_849_2767# 4.53e-21
C4080 a_3799_4118# a_4379_3677# 8.56e-20
C4081 a_2907_2223# a_2249_3543# 3.79e-21
C4082 a_4533_2449# a_3847_3855# 0.691027f
C4083 a_3891_3432# a_1692_4399# 0.007941f
C4084 a_1823_3855# a_2459_4399# 5.34e-19
C4085 b2 a_5779_4943# 4.91e-20
C4086 a_4640_3855# a_3847_3855# 3.73e-20
C4087 a_4287_3855# a_5227_3855# 7.38e-21
C4088 a_4712_3855# a_3072_3311# 1.46e-19
C4089 a_883_2223# a_1308_2223# 1.31e-19
C4090 a_395_2344# a_317_743# 9.06e-20
C4091 a_5002_1501# a_5075_1148# 6.1e-19
C4092 a_553_1679# a_317_2455# 0.020094f
C4093 a_757_6281# a_1508_1135# 4.75e-19
C4094 a_6572_5309# a_6412_5719# 0.005104f
C4095 DVDD a_3571_2767# 1.78557f
C4096 a_1775_4118# a_3076_1135# 4.35e-21
C4097 a_259_1831# a_1251_1501# 0.036295f
C4098 DVDD a_2815_3677# 0.001418f
C4099 a_2412_2767# a_1421_2919# 1.46e-19
C4100 a4 a_5667_4221# 0.002126f
C4101 a_2340_2767# a_849_3017# 7.33e-20
C4102 a_5923_2223# a_6403_1679# 1.26e-19
C4103 DVDD a_4031_5487# 1.29245f
C4104 a_2551_2223# a_1697_743# 0.001913f
C4105 a_4732_3677# a_1865_4013# 2.21e-20
C4106 a_4023_3677# a_3072_3311# 0.022961f
C4107 a_4457_743# a_4625_749# 0.485816f
C4108 a_5587_3133# a4 0.007553f
C4109 a_1125_3017# a_2459_3311# 1.03e-20
C4110 a5 a_883_2589# 0.00296f
C4111 a_2907_2589# a_2375_3311# 4.8e-19
C4112 a0 a_2375_3311# 2.49e-20
C4113 a_4535_854# a_5779_4943# 0.020301f
C4114 a_297_4105# a_443_591# 0.001005f
C4115 b4 a_3983_4520# 0.250257f
C4116 a_2327_3432# b3 1.46e-20
C4117 a_4709_1929# a_4877_1679# 0.010905f
C4118 b0 a_2367_5487# 9.18e-20
C4119 a_248_4631# a_317_5095# 0.005093f
C4120 a_2157_5719# a_2367_5853# 0.04028f
C4121 a_2520_3855# a_2263_957# 1.3e-19
C4122 a_1067_5487# a_1420_5487# 2.18e-19
C4123 a_2980_5487# a_2249_4631# 7.27e-20
C4124 a_1455_6031# a_2375_4399# 1.54e-20
C4125 a_2815_4765# a_3072_4399# 0.023012f
C4126 a_409_3543# a_1079_4399# 4.55e-21
C4127 a2 a_1697_743# 1.37e-20
C4128 a_5264_4943# a_3072_4399# 3.15e-19
C4129 a_5192_4943# a_4399_4943# 0.001143f
C4130 a_5356_2589# a_4268_2767# 9.21e-20
C4131 a_5943_2767# a_5188_2223# 8.11e-19
C4132 a_2493_1679# a_1775_854# 0.003319f
C4133 DVDD a_3655_3133# 0.162385f
C4134 a_757_6281# a_1492_5487# 3.18e-20
C4135 a_1067_5853# a_1420_5853# 2.18e-19
C4136 P9 a_1308_591# 0.00792f
C4137 a_2375_4399# a_5943_2767# 1.84e-20
C4138 a_3537_1367# a_5345_1929# 1.45e-19
C4139 a_3517_5487# a_2283_5487# 0.018676f
C4140 b2 a_711_5853# 3e-20
C4141 a_2980_5487# a_2723_5853# 0.023012f
C4142 DVDD a_5448_957# 4.92e-19
C4143 a5 a_1907_957# 4.77e-20
C4144 a_6219_5309# a_6644_5309# 1.31e-19
C4145 a2 a_5821_5101# 1.05e-20
C4146 a4 a_5345_1679# 3.91e-20
C4147 a_1775_854# a_1865_749# 0.70743f
C4148 a_2325_5713# a_443_4943# 6.88e-20
C4149 b1 a_5219_6397# 1.5e-19
C4150 a_2045_2223# a_3847_3855# 0.002182f
C4151 a_1775_854# a_1823_3855# 0.025326f
C4152 a_2467_2223# a_3072_3311# 3.21e-19
C4153 DVDD a_6219_5309# 0.168607f
C4154 a_995_4399# a_3072_3311# 0.500704f
C4155 a_2520_3855# a_1692_4399# 2.12e-19
C4156 a0 a_3471_6397# 3.93e-20
C4157 a_883_2223# a_685_1367# 0.025247f
C4158 a_5923_2223# a_5503_2767# 0.216988f
C4159 a_3813_3543# a_4471_4399# 1.05e-20
C4160 a_3523_3030# a_4364_2767# 7.33e-20
C4161 b1 a_2459_4399# 7.45e-19
C4162 a_445_3677# a_409_3543# 4.78e-19
C4163 a_2980_5487# a_4180_6031# 7.33e-20
C4164 a_3387_6031# a_3827_6031# 0.06717f
C4165 a_4073_4625# a_3164_2223# 1.42e-20
C4166 a_3983_4520# a_3571_2767# 2.34e-20
C4167 DVDD a_4471_5487# 0.248472f
C4168 a_4533_2449# a_4544_3855# 0.021091f
C4169 a_1823_3855# a_573_4105# 0.001632f
C4170 a_4625_749# a_5023_957# 0.084091f
C4171 b5 a_5188_2223# 0.00155f
C4172 a4 a_1775_854# 0.01716f
C4173 a_2235_1256# a_2244_2767# 1.04475f
C4174 a_4640_3855# a_4544_3855# 0.005686f
C4175 DVDD a_2459_3311# 0.173956f
C4176 a_5413_3133# a_3891_3432# 2.73e-20
C4177 a_4728_4399# a_2235_5608# 4.89e-21
C4178 a_4073_4625# a_3905_5719# 0.001361f
C4179 a_3072_4399# a_4471_5853# 1.48e-20
C4180 a_3983_4520# a_4031_5487# 0.001295f
C4181 a_1823_4943# a_4351_5206# 4.55e-20
C4182 a_3799_4118# a_2283_5487# 0.003003f
C4183 a_961_1831# a_2045_2223# 1.75e-19
C4184 b5 a_2375_4399# 0.032352f
C4185 a_995_4399# a_4379_3311# 8.03e-21
C4186 a_3931_3855# a_4287_3855# 0.008475f
C4187 a_961_1831# a_1037_4625# 0.00838f
C4188 a_1125_3017# a_849_4105# 7.19e-19
C4189 a_1508_1135# a_1251_1501# 0.025052f
C4190 a_1987_2767# a_1508_1135# 1.14e-20
C4191 a1 a_1692_4399# 1.8984f
C4192 a_5837_1831# a_4847_1653# 0.013726f
C4193 a_1039_1942# a_1865_749# 4.44e-20
C4194 b5 a_849_4105# 0.029296f
C4195 a_1039_1942# a_1823_3855# 6.29e-19
C4196 a5 a_4943_1653# 3.78e-20
C4197 a_3164_2223# a_1865_4013# 0.035447f
C4198 a_984_6183# a_443_4943# 0.097971f
C4199 a4 a_573_4105# 0.036465f
C4200 a_2248_6031# a_1329_6183# 2.54e-19
C4201 a1 a_3977_4943# 2.63e-19
C4202 a_2459_3677# a_1865_4013# 7.12e-19
C4203 a_1784_1679# a_2467_2223# 2.75e-19
C4204 a_3072_3311# a_2235_5608# 2.92e-21
C4205 a_4023_3677# a_3891_3432# 0.017809f
C4206 b1 a_1907_6941# 2.97e-19
C4207 a3 a_3148_5853# 4.04e-19
C4208 a_1823_4943# a_1907_5309# 0.030161f
C4209 a_3827_6397# a_627_5487# 6.46e-19
C4210 a_259_1831# a_355_1653# 0.318148f
C4211 a_219_1929# a_317_2455# 0.01201f
C4212 a_4533_2449# a_443_591# 4.85e-20
C4213 a_4180_6397# a_3537_6807# 0.005031f
C4214 a_2325_5713# a_2689_6031# 0.009986f
C4215 a_2263_4943# a_2235_5608# 5.5e-20
C4216 a_4457_743# a_5223_1501# 7.27e-19
C4217 a_5188_2223# a_4268_2767# 0.177246f
C4218 a_6173_2543# a_5188_2223# 0.002446f
C4219 a_2815_3311# a_1125_3017# 1.67e-20
C4220 a_5284_2223# a_4535_854# 1.44e-19
C4221 a4 a_1039_1942# 0.089221f
C4222 a_2375_4399# a_4268_2767# 3.59e-21
C4223 a_6092_4221# a_5653_5095# 0.007578f
C4224 a_757_6281# b0 0.1131f
C4225 a_1365_6397# a0 4.12e-20
C4226 b2 a_2327_4520# 0.020839f
C4227 a_3261_6183# a_4115_5853# 5.02e-19
C4228 a_1527_2045# a_573_4105# 1.57e-20
C4229 P3 a_3905_5719# 2.11e-20
C4230 a_6737_3855# a_1823_4943# 8.26e-20
C4231 a_5837_1831# a_6828_2045# 4.34e-20
C4232 a_5667_3855# a_5653_5095# 0.042404f
C4233 a_1455_6031# a_3827_6397# 0.103484f
C4234 a_961_1831# a_1400_3677# 0.00792f
C4235 a5 a_2327_3432# 0.012723f
C4236 b2 a_395_2344# 0.010192f
C4237 b4 a_2249_3543# 1.82e-19
C4238 b4 a_297_3017# 0.086779f
C4239 a_4943_1653# a_4457_743# 0.607345f
C4240 DVDD a_5188_2223# 0.4679f
C4241 DVDD a_2375_4399# 0.744139f
C4242 a_1527_2045# a_1039_1942# 0.02418f
C4243 a_1697_743# a_5873_1679# 8.13e-20
C4244 a_4457_743# a_5319_1174# 1.07e-19
C4245 a_1697_743# a_2616_957# 2.05e-19
C4246 a2 a_3609_4719# 4.18e-19
C4247 DVDD a_1171_1679# 0.001444f
C4248 a_481_6281# a_1775_6696# 0.004591f
C4249 a_2467_2223# a_3891_3432# 2.11e-19
C4250 P8 a_4751_1831# 0.006671f
C4251 a_995_4399# a_4287_4221# 0.110728f
C4252 a2 a_4931_2223# 4.55e-20
C4253 a_4073_4625# a_4115_5487# 2.45e-21
C4254 a_2520_6575# a_5653_5095# 4.16e-20
C4255 a_1692_4399# a_2417_4625# 0.013591f
C4256 a_995_4399# a_3891_3432# 0.021358f
C4257 b1 a_573_4105# 3.17e-19
C4258 DVDD a_849_4105# 1.25786f
C4259 a_4401_2589# a_3847_3855# 3.07e-19
C4260 a4 a_1125_2767# 3.74e-19
C4261 a_627_5487# a_3072_4399# 6.47e-22
C4262 a_4709_1929# a_2341_2455# 0.006482f
C4263 a0 a_3517_4943# 1.05e-19
C4264 a_3977_4943# a_2417_4625# 5.86e-20
C4265 a_4625_749# a_6047_2045# 0.030161f
C4266 b4 a_5653_5095# 2.68e-20
C4267 a_883_4943# a_443_4943# 0.038342f
C4268 a0 a_849_3017# 2.45e-20
C4269 a_4709_1929# a_2980_1135# 1.84e-19
C4270 b1 a_1039_1942# 1.1e-19
C4271 a_1455_6031# a_3072_4399# 1.57e-20
C4272 a_2341_2455# a_3072_3311# 1.39e-19
C4273 a1 a_5311_4221# 0.001676f
C4274 a_4931_2589# a4 0.002659f
C4275 a_5192_4943# a_4351_5206# 7.33e-20
C4276 b3 a_1421_2919# 0.10972f
C4277 DVDD a_2815_3311# 0.16414f
C4278 b1 a_2283_5487# 0.423805f
C4279 a_1775_854# a_5779_4943# 2.42e-19
C4280 b3 a_443_4943# 5.23e-19
C4281 a_2815_3677# a_2249_3543# 0.054744f
C4282 a3 a_1401_3855# 9.34e-20
C4283 a_2235_1256# a_485_749# 0.006899f
C4284 b5 a_1125_3855# 2.93e-20
C4285 a_2467_2223# a_3827_1679# 0.005557f
C4286 a_2263_6575# a_2157_5719# 5.47e-20
C4287 a_1775_854# a_3471_1679# 0.037506f
C4288 a_355_1653# a_1508_1135# 3.15e-21
C4289 a_3847_3855# a_5289_1433# 6.77e-19
C4290 a3 a_2263_3855# 7.76e-19
C4291 a_5227_3855# a_5075_1148# 2e-20
C4292 a_2327_3432# a_2375_3311# 0.165049f
C4293 a_4379_3311# a_2341_2455# 1.88e-19
C4294 a4 a_5545_2925# 0.054789f
C4295 a_947_4520# a_1508_1135# 0.004444f
C4296 a_3537_1367# a_4252_1679# 0.008715f
C4297 a_3261_6183# a_3537_6807# 0.248698f
C4298 a1 a_4023_3677# 2.57e-20
C4299 a_4751_1831# a_5503_2767# 4.8e-19
C4300 a_1697_743# a_3164_2223# 0.004127f
C4301 a_2235_1256# a_1125_3017# 0.001492f
C4302 a_4943_1653# a_5023_957# 8.81e-20
C4303 a_3517_5487# a_2367_5853# 7.51e-20
C4304 a_4471_4399# a_1692_4399# 0.004612f
C4305 a_3847_3855# a_1775_4118# 3.47e-20
C4306 a_6005_2223# a_4533_2449# 6.87e-20
C4307 a_2375_4399# a_3983_4520# 0.057944f
C4308 a4 a_5923_1135# 2.19e-19
C4309 a_2249_4631# a_4073_4625# 0.057036f
C4310 a_1497_6189# a_3261_6183# 3.94e-21
C4311 a_1784_1679# a_2341_2455# 3.33e-20
C4312 a_2493_1929# a_1775_854# 6.05e-19
C4313 a_3297_2045# a_2467_2223# 9.03e-20
C4314 a_4115_5853# a_4351_5206# 4.09e-19
C4315 P5 a_2263_5309# 0.02283f
C4316 a_2467_2223# a_2520_3855# 0.089249f
C4317 a3 a_4399_4943# 0.001478f
C4318 a_5503_2767# a_6756_2045# 8.78e-20
C4319 a_995_4399# a_2520_3855# 0.05794f
C4320 a_5779_4943# a_2283_5487# 4.2e-19
C4321 a_527_5309# a_443_4943# 0.033764f
C4322 a_355_1653# a_527_957# 3.04e-20
C4323 a_317_2455# a_883_957# 7.36e-22
C4324 a_5653_5095# a_4031_5487# 0.110071f
C4325 a_4399_4943# a_6412_5719# 0.089442f
C4326 a_3827_2045# a_3537_1367# 0.024786f
C4327 a_757_6281# a_1539_6397# 6.28e-22
C4328 a0 a_3983_5608# 0.124879f
C4329 b5 a_3072_4399# 5.32e-19
C4330 a_553_1679# a_1784_1679# 0.08878f
C4331 a_961_1831# a_1775_4118# 0.002681f
C4332 a_1784_1679# a_2980_1135# 0.114012f
C4333 a_2249_4631# a_1865_4013# 0.001201f
C4334 DVDD a_3827_6397# 0.144672f
C4335 a_573_4105# a_2263_4221# 1.33e-21
C4336 a_2459_4399# a_2327_4520# 0.033524f
C4337 a0 a_1860_4399# 1.09e-21
C4338 a4 a_1435_4765# 9.69e-20
C4339 a1 a_995_4399# 0.083624f
C4340 a_1880_2045# a_1775_4118# 4.89e-20
C4341 P0 a_1037_4625# 3.31e-20
C4342 a_1987_3133# a_2340_3133# 2.18e-19
C4343 a_395_854# a_3663_1135# 0.058994f
C4344 a_5173_3631# a_4544_3855# 1.13e-19
C4345 a_5284_2589# a_1697_743# 9.64e-20
C4346 a_2459_3311# a_2249_3543# 0.011205f
C4347 a_757_6281# a_1692_4399# 0.121346f
C4348 a5 a_6412_4007# 2.03e-19
C4349 a_2341_2455# a_3891_3432# 0.01235f
C4350 a2 a_3573_6941# 1.5e-22
C4351 DVDD a_2235_1256# 1.56928f
C4352 a_2520_3855# a_2235_5608# 4.79e-20
C4353 a_4533_2449# a_4625_749# 4.11e-21
C4354 a_3261_6183# a3 0.015556f
C4355 P6 a_5227_3855# 1.77e-19
C4356 a_3240_3311# a_849_4105# 1.18e-19
C4357 P5 a_2157_5719# 6.32e-20
C4358 a_3747_6575# a_3905_5719# 4.42e-20
C4359 a_4103_6575# a_2283_5487# 1.22e-20
C4360 a0 a_1329_6183# 0.141296f
C4361 a_3747_6941# b0 0.003768f
C4362 a_1420_5487# a_443_4943# 3.03e-19
C4363 a_4544_3855# a_5289_1433# 8.3e-20
C4364 a_685_1367# a_1251_1501# 0.054357f
C4365 a_5284_2223# a_1775_854# 4.35e-21
C4366 a_527_4943# a_317_5095# 0.047357f
C4367 a_5863_5309# a_5821_5101# 0.089278f
C4368 a_5689_5309# a_5779_4943# 0.006823f
C4369 a_6572_5309# a_4399_4943# 3.03e-19
C4370 a_6219_5309# a_5653_5095# 0.011819f
C4371 a5 a_1421_2919# 0.176227f
C4372 a_1420_5853# a_443_4943# 7.33e-20
C4373 a_4457_743# a_5873_2045# 2.7e-20
C4374 DVDD a_3072_4399# 1.19036f
C4375 a_5009_6183# a2 0.037235f
C4376 a_2341_2455# a_4860_1367# 1.35e-19
C4377 a5 a_443_4943# 0.010686f
C4378 a1 a_2235_5608# 0.051006f
C4379 a_2815_3311# a_3240_3311# 1.31e-19
C4380 a_4533_2449# a_4805_2767# 6.87e-20
C4381 DVDD a_6403_2045# 0.15618f
C4382 a_2340_2767# a_1775_4118# 5.45e-19
C4383 a_627_5487# a_4471_5853# 3.93e-20
C4384 a_5545_2925# a_5779_4943# 0.178392f
C4385 a_2325_5713# a_3148_5487# 1.66e-20
C4386 b1 a_1435_4765# 0.005122f
C4387 a_4457_743# a_6412_4007# 0.02249f
C4388 a_2341_2455# a_3827_1679# 5.1e-19
C4389 b4 a_4824_5853# 9.54e-21
C4390 a_443_591# a_5289_1433# 0.100141f
C4391 b3 a_905_4765# 8.88e-19
C4392 a_2907_2589# a_2045_2223# 0.005557f
C4393 a_2551_2589# a_2467_2223# 0.059224f
C4394 b0 a_947_4520# 8.45e-19
C4395 a0 a_1037_4625# 0.01535f
C4396 a_995_4399# a_2417_4625# 6.07e-19
C4397 a_2980_5487# a_4115_5853# 2.35e-19
C4398 b2 a_1631_2767# 1.2e-19
C4399 a_5923_1135# a_5779_4943# 0.00664f
C4400 a_481_6281# a_2248_6031# 7.33e-20
C4401 a_2375_4399# a_2249_3543# 6.73e-20
C4402 a_1823_6575# a_2263_5309# 0.111809f
C4403 P10 a_2980_1135# 0.002331f
C4404 a_1775_4118# a_443_591# 5.22e-20
C4405 a_5863_4943# a_4031_5487# 2.34e-20
C4406 b4 a_2412_3133# 1.21e-19
C4407 b0 a_5227_3855# 1.23e-19
C4408 a_5264_4943# b5 7.98e-20
C4409 a_2688_6575# DVDD 4.72e-19
C4410 a_5023_591# a_2980_1135# 0.035925f
C4411 a_961_1831# a_317_743# 0.003554f
C4412 a_2249_3543# a_849_4105# 0.484861f
C4413 a_4751_1831# a_5923_2223# 6.95e-19
C4414 a_297_3017# a_849_4105# 0.002543f
C4415 a_4636_3311# a_3072_3311# 0.003613f
C4416 a_395_2344# a_573_4105# 0.026461f
C4417 a_3523_3030# a_3847_3855# 0.047493f
C4418 a_469_1929# a_317_2455# 0.012078f
C4419 a_3813_3543# a_5227_3855# 7.77e-20
C4420 a_3297_2045# a_2341_2455# 1.77e-20
C4421 b2 a_1775_6696# 0.011573f
C4422 a_2325_5713# a_1508_1135# 2.56e-20
C4423 a_1895_6397# a_1775_6696# 5.51e-19
C4424 a_219_1929# a_1784_1679# 2.75e-20
C4425 a_2341_2455# a_2520_3855# 0.030534f
C4426 a_2616_3855# a_849_4105# 3.98e-19
C4427 a_5837_1831# a_3663_1135# 0.005629f
C4428 a_5135_6031# a_5219_6397# 0.030161f
C4429 a_5009_6183# a_5575_6397# 0.012575f
C4430 a_3387_6031# a_5928_6397# 2.59e-19
C4431 a_2243_1929# a_1952_1679# 1.12e-20
C4432 b4 a_409_3543# 0.10137f
C4433 a5 a_2781_2767# 5e-20
C4434 a_553_1679# a_3297_2045# -5.23e-36
C4435 a_1880_2045# a_317_743# 1.45e-20
C4436 a_3523_3030# a_4732_3311# 4.35e-21
C4437 a_2327_3432# a_849_3017# 5.55e-19
C4438 a_3813_3543# a_4804_3311# 1.05e-19
C4439 a_395_2344# a_1039_1942# 0.002298f
C4440 a_2375_3311# a_1421_2919# 3.05e-19
C4441 a_2327_4520# a_2283_5487# 3.12e-19
C4442 a_553_1679# a_2520_3855# 1.42e-19
C4443 a_2417_4625# a_2235_5608# 7.87e-19
C4444 a_4636_3311# a_4379_3311# 0.02283f
C4445 a5 a_4287_3855# 0.003992f
C4446 a_2520_3855# a_2980_1135# 0.019286f
C4447 a_5188_2223# a_5653_5095# 2.87e-20
C4448 a_2815_3311# a_2249_3543# 0.012262f
C4449 a_2520_6575# a_2157_5719# 0.088248f
C4450 a_2249_4631# a_5821_5101# 0.22508f
C4451 a_2375_4399# a_5653_5095# 0.276948f
C4452 a_3609_4399# a_4399_4943# 5.71e-19
C4453 a_3983_4520# a_3072_4399# 0.105144f
C4454 a_4073_4625# a_1823_4943# 0.474426f
C4455 a_1823_6575# a_2157_5719# 0.016751f
C4456 a_627_5487# a_2688_6941# 0.001135f
C4457 a_995_4399# a_4471_4399# 6.81e-20
C4458 a3 a_4351_5206# 8.06e-20
C4459 b1 a_1079_4399# 9.05e-20
C4460 a_2367_5487# a_2235_5608# 0.033151f
C4461 a0 a_905_4399# 3.44e-20
C4462 a_4896_5853# a_3905_5719# 9.21e-20
C4463 a_4824_5853# a_4031_5487# 3.73e-20
C4464 a_2244_2767# a_485_749# 3.26e-20
C4465 a_2193_5487# a_2283_5487# 0.006823f
C4466 a_5837_1831# a_6368_2767# 0.008552f
C4467 a_4351_5206# a_6412_5719# 1.11e-19
C4468 a_4103_6941# a_4456_6941# 2.18e-19
C4469 a_2616_4221# a_1775_4118# 4.95e-20
C4470 a_984_6183# a_1508_1135# 1.7e-20
C4471 a_355_1653# a_685_1367# 0.046063f
C4472 a_317_2455# a_1236_2589# 2.54e-19
C4473 DVDD a_2815_4765# 8.16e-19
C4474 a_259_1831# b3 0.003502f
C4475 a_2325_5713# a_1492_5487# 1.23e-20
C4476 a_1125_3017# a_2244_2767# 0.138145f
C4477 DVDD a_3332_2223# 4.72e-19
C4478 a_1865_4013# a_1823_4943# 0.06507f
C4479 a_6047_1679# a_3663_1135# 0.003919f
C4480 a_3387_6031# a_2520_6575# 0.005466f
C4481 a_6403_1679# a_6828_1679# 8.12e-20
C4482 b4 a_3663_1135# 1.29e-20
C4483 a_1733_4943# a_1823_4943# 0.006958f
C4484 a3 a_1907_5309# 9.96e-20
C4485 b5 a_2244_2767# 3.78e-20
C4486 a_4943_1653# a_4533_2449# 0.071641f
C4487 a_2980_5487# a_3537_6807# 0.111442f
C4488 a_1455_6031# a_627_5487# 0.045112f
C4489 a_3387_6031# a_1823_6575# 4.03e-21
C4490 a_3655_2767# a_3571_2767# 0.06991f
C4491 a_4011_2767# a_3164_2223# 0.044609f
C4492 a_1784_1679# a_2723_1501# 0.044609f
C4493 a1 a_317_5095# 0.302316f
C4494 a_3261_6183# a_3609_4399# 1.51e-20
C4495 a_3387_6031# b4 0.081927f
C4496 a_1455_6031# a_2320_6397# 3.76e-19
C4497 b0 a_2320_6031# 9.58e-20
C4498 a0 a_5192_5309# 4.72e-20
C4499 a_4483_5309# a_4839_5309# 0.009846f
C4500 a_4115_4399# a_2283_5487# 1.48e-19
C4501 b5 a_1907_3855# 0.002408f
C4502 a_3827_6397# a_4252_6397# 1.31e-19
C4503 a_1037_4625# a_1067_5487# 1.86e-20
C4504 b5 a_5265_4719# 1.29e-19
C4505 a_1497_6189# a_2980_5487# 2.61e-20
C4506 DVDD a_619_3677# 0.037111f
C4507 b5 a_6092_3855# 2e-20
C4508 a1 a_1079_4765# 0.002559f
C4509 a_5413_2767# a_3663_1135# 5.11e-20
C4510 a_984_6183# a_1492_5487# 0.007578f
C4511 a_1037_4625# a_1067_5853# 9.37e-21
C4512 a_3523_3030# a_4544_3855# 0.013903f
C4513 a0 a_5265_5807# 1.52e-19
C4514 a_1697_743# a_4103_1135# 0.02283f
C4515 a_2244_2767# a_4268_2767# 3.99e-20
C4516 a_2467_2223# a_3148_1135# 3.05e-20
C4517 a_757_6281# a_995_4399# 0.744456f
C4518 a_4636_3311# a_3891_3432# 0.127049f
C4519 a_984_6183# a_1492_5853# 0.008114f
C4520 a_3813_3543# a_3931_3855# 2.21e-19
C4521 a_317_743# a_443_591# 0.774404f
C4522 a_2551_2589# a_2341_2455# 0.04028f
C4523 a_763_1256# P9 0.001262f
C4524 DVDD a_4471_5853# 0.046154f
C4525 a5 a_297_3855# 5.27e-20
C4526 a_3537_1367# a_3747_1135# 0.011205f
C4527 b2 a_3847_3855# 0.030557f
C4528 a3 a_3241_6895# 5.9e-19
C4529 a_2157_5719# a_4031_5487# 2.38e-19
C4530 a_4351_5206# a_4824_5487# 0.005423f
C4531 a_5177_1929# a_4535_854# 0.001607f
C4532 a_3571_2767# a_3663_1135# 0.292222f
C4533 a_2235_1256# a_2249_3543# 3.12e-21
C4534 DVDD a_2244_2767# 0.810233f
C4535 a_3983_4520# a_2815_4765# 1.34e-20
C4536 a_2249_4631# a_3609_4719# 2.25e-19
C4537 b4 a_1631_3133# 0.003455f
C4538 b5 a_627_5487# 3.92e-19
C4539 a_2375_4399# a_3240_4765# 1.73e-19
C4540 DVDD a_1733_5309# 4.95e-19
C4541 a_2325_5713# b0 5.7e-19
C4542 a_947_4520# a_1692_4399# 0.08973f
C4543 a_6047_2045# a_6412_4007# 8.51e-19
C4544 b2 a_4732_3311# 7.38e-20
C4545 a0 a_1775_4118# 1.45e-19
C4546 a_5863_4943# a_2375_4399# 0.002839f
C4547 a0 a_4896_5487# 4.64e-20
C4548 b2 a_961_1831# 0.071371f
C4549 a_2907_2589# a_1775_4118# 2.27e-22
C4550 b4 a_975_3677# 0.001128f
C4551 a5 a_1328_3677# 2.53e-19
C4552 a_1697_743# a_3148_1501# 3.14e-19
C4553 a_2980_5487# a3 0.058921f
C4554 b3 a_1508_1135# 0.040028f
C4555 a_4535_854# a_3847_3855# 0.024219f
C4556 a_5135_6031# a_2283_5487# 8.66e-20
C4557 a_5009_6183# a_3905_5719# 1.08e-19
C4558 a_757_6281# a_2235_5608# 2.38e-20
C4559 a_3387_6031# a_4031_5487# 0.046045f
C4560 DVDD a_1907_3855# 0.001422f
C4561 a_4457_743# a_3537_1367# 5.09e-19
C4562 a_2243_1929# a_1697_743# 0.008864f
C4563 DVDD a_6368_3133# 8.04e-19
C4564 a_5095_1929# a_2980_1135# 1.86e-20
C4565 a_3571_2767# a_4103_1501# 0.009381f
C4566 a_4625_749# a_5289_1433# 0.018735f
C4567 a_2249_3543# a_3072_4399# 1.64e-20
C4568 a_3757_4221# a_1823_4943# 3.33e-20
C4569 a1 a_3471_6031# 0.003567f
C4570 DVDD a_6092_3855# 1.02e-19
C4571 a_1865_4013# a_2459_4765# 3.24e-20
C4572 a_3517_5487# a_3941_5853# 2.34e-19
C4573 a_5227_3855# a_1692_4399# 0.701188f
C4574 a_961_1831# a_895_1135# 9.26e-21
C4575 a_6296_2767# a_5503_2767# 3.7e-19
C4576 a2 a_4728_4399# 0.028012f
C4577 a_3260_2223# a_1865_4013# 1.38e-20
C4578 a_4436_2767# a_2341_2455# 1.3e-19
C4579 a2 a_4709_1929# 4.58e-20
C4580 a_395_854# a_1865_749# 0.221652f
C4581 a_317_743# a_353_957# 5.12e-20
C4582 a_1823_3855# a_395_854# 3.4e-20
C4583 b5 a_5943_2767# 8.08e-20
C4584 a5 a_259_1831# 0.002363f
C4585 a_6572_4943# a_6412_5719# 0.005587f
C4586 a_2327_3432# a_2045_2223# 0.003438f
C4587 a_1697_743# a_1823_4943# 3.4e-19
C4588 b4 a_4436_3133# 4.85e-20
C4589 a_1421_2919# a_297_4105# 5.08e-22
C4590 a_2327_3432# a_1037_4625# 2.55e-19
C4591 a_1907_6941# a_1775_6696# 0.020245f
C4592 a_1125_3017# a_485_749# 2.87e-22
C4593 a_984_6183# b0 9.58e-19
C4594 a_481_6281# a0 0.046296f
C4595 a_5448_957# a_3663_1135# 1.73e-20
C4596 a_2375_3311# a_3537_1367# 2.55e-19
C4597 a_3523_3030# a_3471_2045# 1.14e-20
C4598 a_259_1831# a_721_1135# 0.006823f
C4599 a_2907_2223# a4 1.42e-19
C4600 a2 a_3072_3311# 0.004358f
C4601 a_4103_6941# a_3983_5608# 7.01e-21
C4602 a_3261_6183# a_4180_6397# 1.44e-19
C4603 a_3571_2767# a_4456_1135# 2.59e-19
C4604 a_3609_4399# a_4351_5206# 0.008182f
C4605 a4 a_395_854# 3.76e-21
C4606 a2 a_2263_4943# 2.78e-19
C4607 a_5448_591# a_443_591# 2.21e-19
C4608 a_5356_2589# a_3663_1135# 4.97e-20
C4609 DVDD a_627_5487# 1.69754f
C4610 a_3072_4399# a_5653_5095# 0.018101f
C4611 a_501_5719# a_527_4943# 2.74e-20
C4612 a_2327_4520# a_2367_5853# 1.07e-21
C4613 a0 a_1861_5807# 4.92e-19
C4614 a_1823_4943# a_5821_5101# 0.001421f
C4615 a_1421_2919# a_849_3017# 0.834239f
C4616 DVDD a_6756_1679# 1.31e-19
C4617 a_763_1256# a_1171_2045# 0.03031f
C4618 a_501_5719# a_1895_6031# 0.059255f
C4619 b5 a_1125_3017# 2.88e-21
C4620 a_5009_6183# a_5863_5309# 0.002263f
C4621 a_5135_6031# a_5689_5309# 6.76e-21
C4622 a_2320_6397# DVDD 4.72e-19
C4623 a_6403_2045# a_6828_2045# 1.31e-19
C4624 a_2520_3855# a_2723_1501# 0.008759f
C4625 b2 a_4544_3855# 0.061204f
C4626 a1 a_4636_3311# 1.98e-20
C4627 a_1455_6031# DVDD 1.45841f
C4628 a_1631_2767# a_573_4105# 0.033252f
C4629 DVDD a_1676_1135# 9.68e-19
C4630 a_1497_6189# P2 4.88e-20
C4631 a_2412_3133# a_849_4105# 1.38e-19
C4632 a_553_1679# a_2263_591# 3.35e-21
C4633 a5 a_1400_3311# 2.36e-20
C4634 a_5943_3133# a_4728_4399# 7.41e-21
C4635 a_3517_5487# a_2520_6575# 0.00113f
C4636 a_3983_4520# a_5265_4719# 0.009911f
C4637 DVDD a_5943_2767# 0.00109f
C4638 b0 a_4824_4765# 1.16e-20
C4639 a_1039_1942# a_1631_2767# 0.070739f
C4640 a_1125_3017# a_4268_2767# 8.62e-21
C4641 a_3523_3030# a_4471_4765# 5.33e-21
C4642 a_1907_4221# a_1823_4943# 0.001076f
C4643 a_4535_854# a_4544_3855# 0.244298f
C4644 P9 a_1236_957# 0.004869f
C4645 b4 a_3517_5487# 6.21e-20
C4646 b5 a_4268_2767# 0.006237f
C4647 a_3148_1135# a_2980_1135# 0.007718f
C4648 a_409_3543# a_849_4105# 3.58e-20
C4649 b1 a_4839_4943# 8e-19
C4650 a_5311_4221# a_5227_3855# 0.030161f
C4651 DVDD a_485_749# 0.559389f
C4652 a_5413_3133# a_5227_3855# 4.48e-20
C4653 a_1865_4013# a_3240_4399# 7.16e-20
C4654 a_895_1135# a_443_591# 3.27e-19
C4655 a_4712_3855# a_5227_3855# 4.35e-20
C4656 a5 a_1508_1135# 0.052729f
C4657 b0 a_883_4943# 2.54e-19
C4658 a0 a_1236_4943# 8.12e-19
C4659 a3 a_353_4943# 1.12e-20
C4660 a_757_6281# a_317_5095# 0.028297f
C4661 DVDD a_1125_3017# 1.50552f
C4662 a_2375_4399# a_2157_5719# 2.68e-20
C4663 a_1775_6696# a_2283_5487# 4.62e-19
C4664 a_763_1256# a_1697_743# 8.87e-19
C4665 a2 a_1895_6031# 4.17e-20
C4666 a4 a_6092_4221# 8.59e-21
C4667 a_4379_3677# a_3847_3855# 0.002913f
C4668 a_4732_3677# a_3072_3311# 9.62e-20
C4669 a_5188_2223# a_3663_1135# 0.004247f
C4670 a_4535_854# a_443_591# 0.036838f
C4671 b0 b3 0.171241f
C4672 DVDD b5 1.2986f
C4673 a0 P1 0.027001f
C4674 a_5837_1831# a4 0.001129f
C4675 a_3260_2223# a_1697_743# 7.42e-20
C4676 b1 P5 0.006977f
C4677 a0 a_3523_3030# 7.49e-21
C4678 a4 a_5667_3855# 0.001761f
C4679 a_4625_749# a_317_743# 5.55e-20
C4680 a_3813_3543# b3 3.03e-19
C4681 b4 a_3799_4118# 0.097742f
C4682 a_4011_3133# a_4364_3133# 2.18e-19
C4683 a2 a_3891_3432# 0.03278f
C4684 a_757_6281# a_1079_4765# 0.045895f
C4685 a_297_3017# a_619_3677# 0.017903f
C4686 a_395_2344# a_445_3677# 0.00697f
C4687 a_4457_743# a_5075_1148# 0.032227f
C4688 a_2157_5719# a_3076_5853# 8.59e-19
C4689 a_6005_1135# a_5075_1148# 4.06e-19
C4690 a_5009_6183# a_2249_4631# 0.001458f
C4691 a3 a_619_3311# 1.27e-19
C4692 a_1455_6031# a_3983_4520# 2.97e-21
C4693 a_6173_1455# a_5923_1135# 0.007234f
C4694 a_3240_4765# a_3072_4399# 0.00792f
C4695 a_2980_5487# a_3609_4399# 1.35e-19
C4696 a_3387_6031# a_2375_4399# 3.17e-20
C4697 a_2325_5713# a_1692_4399# 9.82e-20
C4698 a_1823_6575# a_1823_3855# 1.31e-20
C4699 a_627_5487# a_537_5487# 0.006823f
C4700 P11 a_2520_3855# 0.014778f
C4701 a_1907_4943# a_1823_6575# 0.033252f
C4702 a_1308_4943# a_627_5487# 5.86e-20
C4703 a_5689_4943# a_4399_4943# 1.46e-19
C4704 a_5177_1929# a_1775_854# 0.005075f
C4705 b4 a_1823_3855# 0.02976f
C4706 a_627_5487# a_537_5853# 0.006958f
C4707 a4 a_2520_6575# 5.43e-21
C4708 DVDD a_4268_2767# 0.624519f
C4709 a2 a_4860_1367# 1.67e-21
C4710 DVDD a_6173_2543# 7.09e-20
C4711 P3 a_3537_6807# 0.112895f
C4712 a_947_4520# a_995_4399# 0.160472f
C4713 a_1329_6183# a_443_4943# 1.11e-19
C4714 a_3517_5487# a_4031_5487# 0.016328f
C4715 a_2980_5487# a_3148_5853# 0.00792f
C4716 b1 a_1236_5309# 1.3e-19
C4717 b0 a_527_5309# 0.008216f
C4718 a_501_5719# a1 0.024972f
C4719 a_1775_854# a_3847_3855# 0.266622f
C4720 a_2244_2767# a_2249_3543# 0.001355f
C4721 a5 P6 1.7e-19
C4722 DVDD a_6644_5309# 4.8e-19
C4723 b4 a4 2.42719f
C4724 a_2244_2767# a_2616_3855# 4.69e-20
C4725 a_995_4399# a_5227_3855# 3.8e-19
C4726 a_297_4105# a_297_3855# 0.010014f
C4727 a_2375_3311# a_1508_1135# 0.001011f
C4728 b1 a_3168_4399# 3.1e-19
C4729 a_2327_3432# a_1775_4118# 0.017977f
C4730 a_2551_2223# a_2520_3855# 0.007272f
C4731 a_4073_4625# a_5503_2767# 2.1e-19
C4732 a_3799_4118# a_3571_2767# 9.59e-20
C4733 a_3387_6031# a_4252_6031# 3.2e-19
C4734 a_4544_3855# a_5667_4221# 1.02e-20
C4735 a_5587_3133# a_4544_3855# 0.011313f
C4736 a_4847_1653# a_2244_2767# 2.95e-19
C4737 a_2045_2223# a_1421_2919# 0.009294f
C4738 b3 a_685_1367# 0.085233f
C4739 a_4399_4943# a_4351_5206# 0.154744f
C4740 a_5943_3133# a_3891_3432# 0.001701f
C4741 a_5137_3855# a_4544_3855# 3.92e-19
C4742 a_4728_4399# a_3905_5719# 1.73e-20
C4743 a_961_1831# a_1775_854# 8.11e-19
C4744 a_1037_4625# a_1421_2919# 0.002173f
C4745 a_3799_4118# a_4031_5487# 0.004391f
C4746 b5 a_3983_4520# 0.028521f
C4747 a_4287_3855# a_4640_3855# 2.18e-19
C4748 a_3891_3432# a_5311_3855# 0.001613f
C4749 a4 a_5413_2767# 2.33e-19
C4750 a1 a_1860_4765# 1.68e-19
C4751 a_5023_957# a_5075_1148# 4.43e-19
C4752 a_1037_4625# a_443_4943# 0.001121f
C4753 a_5376_957# a_443_591# 9.78e-20
C4754 a_1508_1135# a_1676_1501# 0.008292f
C4755 a_961_1831# a_997_1679# 4.78e-19
C4756 a_1907_957# a_317_743# 0.003196f
C4757 a_5503_2767# a_1865_4013# 1.06e-21
C4758 a_4379_3677# a_4544_3855# 1.79e-19
C4759 a_685_1367# a_1328_3311# 2.13e-20
C4760 a_5448_591# a_4625_749# 8.99e-20
C4761 a_3571_2767# a_1865_749# 0.002186f
C4762 a_3164_2223# a_3072_3311# 0.001373f
C4763 b1 a_2520_6575# 7.86e-20
C4764 a_961_1831# a_573_4105# 0.021522f
C4765 a_4732_3677# a_3891_3432# 2.11e-19
C4766 a_2459_3677# a_3072_3311# 2.72e-19
C4767 a3 a_1865_4013# 0.038019f
C4768 a_3847_3855# a_2283_5487# 7.06e-21
C4769 b0 a_1420_5487# 2e-20
C4770 a_1823_4943# a_2616_5309# 4.35e-21
C4771 a_5227_3855# a_2235_5608# 2.42e-20
C4772 a_1733_6575# a0 6.39e-20
C4773 a3 a_1733_4943# 3.38e-19
C4774 b5 a_537_5487# 5.15e-21
C4775 b1 a_1823_6575# 0.052322f
C4776 b0 a_1420_5853# 4.09e-20
C4777 a5 a_1308_2223# 1.39e-20
C4778 a_2815_4765# a_3240_4765# 8.12e-20
C4779 a_4023_3311# a_3571_2767# 3.87e-19
C4780 a_4379_3311# a_3164_2223# 1.53e-19
C4781 a_3983_4520# a_4268_2767# 7.6e-21
C4782 a_6092_4221# a_5779_4943# 2.7e-20
C4783 a4 a_3571_2767# 0.058171f
C4784 a_5837_1831# a_5779_4943# 0.804445f
C4785 a_961_1831# a_1039_1942# 1.2547f
C4786 a2 a1 0.087464f
C4787 a3 P3 3.74e-20
C4788 b1 b4 0.027367f
C4789 a_1895_6397# a0 0.005943f
C4790 b0 a5 0.424749f
C4791 a0 b2 0.315502f
C4792 a_2815_3677# a4 1.06e-19
C4793 a_6092_3855# a_5653_5095# 0.008126f
C4794 b2 a_2907_2589# 8.91e-21
C4795 a_3261_6183# a_4351_5206# 8.56e-21
C4796 a4 a_4031_5487# 0.034005f
C4797 a_2980_5487# a_4180_6397# 2.59e-19
C4798 a_259_1831# a_297_4105# 0.008243f
C4799 a_1455_6031# a_4252_6397# 1.95e-21
C4800 a_3387_6031# a_3827_6397# 0.003858f
C4801 a5 a_3813_3543# 0.010583f
C4802 a_5219_6031# a_4031_5487# 0.036908f
C4803 a_4728_4399# a_5863_5309# 2.31e-20
C4804 b2 a_2723_5487# 4.36e-19
C4805 DVDD a_353_2589# 6.47e-19
C4806 a_3573_1501# a_3663_1135# 0.006958f
C4807 a_4011_3133# a_1865_4013# 1.23e-19
C4808 a_1784_1679# a_3164_2223# 4.81e-20
C4809 a_1880_2045# a_1039_1942# 2.59e-19
C4810 a_2235_1256# a_3663_1135# 9.1e-19
C4811 DVDD a_3983_4520# 0.70256f
C4812 a_1697_743# a_6403_1679# 1.48e-19
C4813 a_1775_854# a_4544_3855# 2.37e-19
C4814 a_1401_6895# a_1329_6183# 0.009374f
C4815 a_883_591# a_317_743# 0.049148f
C4816 a_259_1831# a_849_3017# 6.95e-20
C4817 a3 a_1171_2045# 2.86e-19
C4818 a_527_591# a_395_854# 0.017809f
C4819 a0 a_4535_854# 1.25e-20
C4820 DVDD a_1880_1679# 5.96e-19
C4821 a_2157_5719# a_3072_4399# 3.02e-21
C4822 a_2520_6575# a_5779_4943# 0.002257f
C4823 a_995_4399# a_4640_4221# 9.11e-21
C4824 a_4103_1135# a_4528_1135# 1.31e-19
C4825 a0 a_1788_4765# 1.24e-19
C4826 a_4533_2449# a_3537_1367# 3.55e-19
C4827 a_995_4399# a_3931_3855# 0.033252f
C4828 b3 a_1692_4399# 0.062183f
C4829 a_2235_1256# a_2367_1135# 0.033026f
C4830 a_4931_2589# a_3847_3855# 0.005557f
C4831 a_4493_591# a_1697_743# 4.59e-21
C4832 a_2243_1929# a_2723_1135# 1.22e-19
C4833 a_4483_4943# a_2417_4625# 3.01e-20
C4834 a_961_1831# a_1125_2767# 1.6e-19
C4835 a0 a_4309_4943# 2.33e-19
C4836 a_6047_1679# a_5779_4943# 0.018495f
C4837 DVDD a_537_5487# 5.29e-19
C4838 a_3977_4943# b3 2.48e-19
C4839 a_2467_2223# a_3168_3677# 4.33e-20
C4840 b4 a_5779_4943# 2.29e-20
C4841 a_1037_4625# a_3240_3677# 1.61e-21
C4842 a_395_2344# a_395_854# 8.71e-19
C4843 a_553_1679# a_355_1653# 0.004662f
C4844 a_4625_749# a_4535_854# 0.699809f
C4845 DVDD a_537_5853# 2.01e-19
C4846 a_2980_5487# a_4399_4943# 6.47e-20
C4847 a_2341_2455# a_5227_3855# 3.07e-19
C4848 a_2459_3311# a_1823_3855# 0.006947f
C4849 a_3387_6031# a_3072_4399# 1.66e-20
C4850 a_1775_854# a_443_591# 0.002794f
C4851 a4 a_6219_5309# 6.37e-20
C4852 a_5356_2589# a4 1.67e-19
C4853 a1 a_6020_4221# 1.03e-19
C4854 a_297_3017# a_1125_3017# 8.64e-20
C4855 a_3571_2767# a_3931_4221# 5.88e-20
C4856 a_763_1256# a_895_1501# 0.024135f
C4857 a1 a_2815_4399# 0.003018f
C4858 a2 a_2417_4625# 0.267973f
C4859 a_3164_2223# a_4287_4221# 1.16e-20
C4860 b1 a_4031_5487# 0.001442f
C4861 a_1125_3017# a_2249_3543# 0.002598f
C4862 DVDD a_3240_3311# 6.66e-19
C4863 a_2340_2767# a_1039_1942# 3.73e-20
C4864 a1 a_5311_3855# 3.25e-19
C4865 P5 a_2327_4520# 0.008511f
C4866 a_3164_2223# a_3891_3432# 0.007808f
C4867 b4 a_527_2589# 0.001049f
C4868 a5 a_685_1367# 0.008761f
C4869 a_4544_3855# a_2283_5487# 7.9e-21
C4870 a_2688_6575# a_2157_5719# 4.65e-20
C4871 a_317_743# a_1604_1501# 1.25e-19
C4872 b5 a_2249_3543# 0.016499f
C4873 a_2325_5713# a_995_4399# 3.15e-20
C4874 a_297_3017# b5 0.058797f
C4875 a_1775_854# a_4180_1679# 0.001281f
C4876 a_2467_2223# a_4252_1679# 6.11e-20
C4877 a_5943_2767# a_5653_5095# 2.68e-20
C4878 a_5413_2767# a_5779_4943# 1.08e-19
C4879 a_4804_3311# a_2341_2455# 2.25e-19
C4880 a_2375_3311# a_3813_3543# 0.008266f
C4881 a_2327_3432# a_3523_3030# 1.62e-19
C4882 a_6572_4943# a_4399_4943# 1.1e-19
C4883 a_248_4631# a_1823_4943# 7.08e-20
C4884 a_947_4520# a_317_5095# 0.004969f
C4885 a_1823_6575# a_2263_4221# 5.07e-21
C4886 a2 a_2367_5487# 0.008305f
C4887 b5 a_2616_3855# 2.39e-19
C4888 a_3573_6575# a_627_5487# 6.17e-20
C4889 a_3747_6575# a_3537_6807# 0.012072f
C4890 a_3537_1367# a_4793_1679# 7.99e-20
C4891 a_685_1367# a_721_1135# 5.12e-20
C4892 a_2520_3855# a_2616_957# 2.61e-20
C4893 a_1697_743# a_5503_2767# 6.12e-20
C4894 a2 a_5095_1929# 3.51e-20
C4895 a_3517_5487# a_3076_5853# 1.79e-19
C4896 a_4896_4399# a_1692_4399# 1.13e-19
C4897 b5 a_4847_1653# 5.24e-21
C4898 a_297_4105# a_1508_1135# 6.47e-20
C4899 a_1039_1942# a_443_591# 1.67e-20
C4900 a_947_4520# a_1079_4765# 0.017809f
C4901 a_2249_4631# a_4728_4399# 0.173238f
C4902 a_2375_4399# a_3799_4118# 0.058773f
C4903 a_3609_4399# a_4073_4625# 0.460696f
C4904 a_2980_5487# a_3261_6183# 0.854494f
C4905 P9 a_1733_591# 7.56e-20
C4906 a_4471_5853# a_4824_5853# 2.18e-19
C4907 a_1527_1679# a_1952_1679# 8.12e-20
C4908 a_3471_2045# a_1775_854# 0.003744f
C4909 a_3827_2045# a_2467_2223# 0.017703f
C4910 b2 a_1067_5853# 5.58e-20
C4911 a_2688_591# a_2263_591# 8.12e-20
C4912 DVDD a_353_591# 6.47e-19
C4913 a_849_3017# a_1508_1135# 0.027016f
C4914 a_995_4399# a_2688_4221# 3.72e-19
C4915 a_3537_1367# a_4180_2045# 0.005093f
C4916 a_1421_2919# a_1775_4118# 0.025635f
C4917 a_3571_2767# a_3471_1679# 9.27e-19
C4918 a_5821_5101# a_6412_5719# 0.073028f
C4919 a_3827_2045# a_4252_2045# 1.31e-19
C4920 a_5779_4943# a_4031_5487# 0.019633f
C4921 a_984_6183# a_995_4399# 9.85e-20
C4922 a_757_6281# a_501_5719# 0.22644f
C4923 a_2325_5713# a_2235_5608# 0.953071f
C4924 a_553_1679# a_1952_2045# 4.72e-19
C4925 b5 a_5653_5095# 0.003158f
C4926 a_3983_5608# a_4839_5309# 6.73e-19
C4927 a2 a_4471_4399# 4.51e-19
C4928 a_2249_4631# a_3072_3311# 3.47e-20
C4929 a_3609_4399# a_1865_4013# 0.001037f
C4930 a_2375_4399# a_1823_3855# 3.59e-20
C4931 a_2157_5719# a_2815_4765# 1.54e-20
C4932 DVDD a_4252_6397# 4.72e-19
C4933 a0 a_5667_4221# 3.26e-19
C4934 a_4847_1653# a_4268_2767# 4.57e-20
C4935 a0 a_5587_3133# 4.25e-20
C4936 a_2263_4943# a_2249_4631# 5.81e-19
C4937 a_3168_4399# a_2327_4520# 4.95e-20
C4938 a_1236_2223# a_685_1367# 0.005104f
C4939 a_2815_4399# a_2417_4625# 0.079996f
C4940 a_619_3677# a_409_3543# 0.041843f
C4941 DVDD a_2249_3543# 0.631909f
C4942 DVDD a_297_3017# 1.77712f
C4943 b1 a_4471_5487# 1.23e-19
C4944 a_1823_3855# a_849_4105# 0.657892f
C4945 a4 a_5188_2223# 0.01133f
C4946 a_4625_749# a_5376_957# 6.41e-19
C4947 a4 a_2375_4399# 0.085581f
C4948 a_5545_2925# a_4544_3855# 0.463113f
C4949 a_3164_2223# a_2520_3855# 8.08e-20
C4950 a_2244_2767# a_2412_3133# 0.007578f
C4951 a_3799_4118# a_4252_6031# 5.21e-22
C4952 a5 a_1692_4399# 0.010779f
C4953 a_757_6281# a_1860_4765# 3.15e-19
C4954 a3 a_1907_4221# 0.019531f
C4955 a_2459_3677# a_2520_3855# 0.004242f
C4956 DVDD a_4847_1653# 0.27768f
C4957 a_4023_3311# a_849_4105# 9.01e-20
C4958 a_984_6183# a_2235_5608# 2.1e-19
C4959 a4 a_849_4105# 0.100733f
C4960 a_481_6281# a_443_4943# 0.001642f
C4961 b2 a_4943_1653# 5.01e-20
C4962 a_5009_6183# a_5192_4943# 0.005587f
C4963 a0 a_1907_6941# 1.6e-19
C4964 a_4931_2589# a_443_591# 1.56e-20
C4965 a_4456_6941# b0 1.43e-19
C4966 a_685_1367# a_1676_1501# 3.28e-19
C4967 a_3655_2767# a_2244_2767# 1.16e-19
C4968 a_3827_6397# a_3517_5487# 0.001583f
C4969 a_219_1929# a_355_1653# 0.095646f
C4970 a_4533_2449# a_5075_1148# 1.41e-19
C4971 a_763_1256# a_317_2455# 0.00591f
C4972 a_1823_6575# a_2327_4520# 0.009764f
C4973 a_6644_5309# a_5653_5095# 2.39e-20
C4974 a_2244_2767# a_409_3543# 5.46e-21
C4975 a_6219_5309# a_5779_4943# 0.004262f
C4976 a_5356_2589# a_5779_4943# 8.37e-20
C4977 a1 a_3164_2223# 4.8e-20
C4978 DVDD a_5653_5095# 0.924148f
C4979 a1 a_3905_5719# 0.351536f
C4980 a_1365_6397# b0 1.76e-20
C4981 a_757_6281# a2 3.49e-20
C4982 DVDD a_6828_2045# 4.72e-19
C4983 a_4943_1653# a_4535_854# 0.195346f
C4984 a_1823_6575# a_2193_5487# 4.66e-20
C4985 a4 a_2815_3311# 9.42e-19
C4986 b2 a_2327_3432# 0.157851f
C4987 b4 a_395_2344# 0.040386f
C4988 a_4709_1929# a_4103_1135# 2.66e-20
C4989 a_2341_2455# a_4252_1679# 5.53e-20
C4990 a_395_2344# a_1251_1135# 1.24e-20
C4991 a_3260_2589# a_2467_2223# 2.93e-20
C4992 a_3332_2589# a_2045_2223# 6.11e-20
C4993 a_4625_749# a_5345_1679# 4.7e-20
C4994 b1 a_2375_4399# 0.046731f
C4995 a_995_4399# a_4483_5309# 1.59e-21
C4996 a_1697_743# a_2688_957# 1.93e-19
C4997 b3 a_2467_2223# 7.47e-19
C4998 a_2980_5487# a_4351_5206# 1.92e-20
C4999 b3 a_995_4399# 0.485085f
C5000 a_4471_4765# a_2283_5487# 1.74e-19
C5001 a_4636_3311# a_5345_1929# 1.88e-20
C5002 a_4115_4765# a_3905_5719# 7.5e-21
C5003 a_4401_2589# a_3537_1367# 8.58e-20
C5004 a_2244_2767# a_3663_1135# 0.007472f
C5005 a_2263_6575# a_1775_6696# 0.012218f
C5006 a_2249_4631# a_3891_3432# 2.87e-21
C5007 a0 a_573_4105# 2.73e-20
C5008 DVDD a_1733_4221# 4.94e-19
C5009 a_6219_4943# a_6412_5719# 0.023045f
C5010 b1 a_849_4105# 0.029388f
C5011 b0 a_297_4105# 0.001932f
C5012 a_3573_6575# DVDD 4.94e-19
C5013 a_4667_591# a_4751_1831# 1.68e-19
C5014 a_1421_2919# a_317_743# 1.51e-19
C5015 a_2375_3311# a_1692_4399# 1.11e-19
C5016 a_4625_749# a_1775_854# 5.26e-19
C5017 a_4636_3311# a_5227_3855# 0.02043f
C5018 a_3827_2045# a_2341_2455# 0.002008f
C5019 a_3387_6031# a_3297_6031# 0.00719f
C5020 a_2235_1256# a_2493_1679# 9.12e-19
C5021 a_1697_743# a_1527_1679# 4.52e-19
C5022 a_5135_6031# a_5928_6397# 4.35e-21
C5023 a_5009_6183# a_6000_6397# 4.34e-20
C5024 a_1236_4943# a_443_4943# 3.73e-20
C5025 a_3164_2223# a_2417_4625# 9.21e-21
C5026 a_2263_3855# a_1865_4013# 0.045338f
C5027 b0 a_849_3017# 4.41e-21
C5028 a_2244_2767# a_4103_1501# 1.97e-19
C5029 a5 a_5311_4221# 6.09e-19
C5030 a_2459_3677# a_2417_4625# 2.1e-21
C5031 a_4636_3311# a_4804_3311# 0.007578f
C5032 a0 a_2283_5487# 0.083771f
C5033 a3 a_2688_5309# 7.42e-20
C5034 a_301_1929# a_297_4105# 0.001547f
C5035 a_4309_5309# a_2283_5487# 1.28e-19
C5036 a_2417_4625# a_3905_5719# 0.004342f
C5037 a_3537_1367# a_5289_1433# 3.96e-20
C5038 P1 a_443_4943# 0.049027f
C5039 b3 a_2235_5608# 0.043593f
C5040 a5 a_4712_3855# 2.1e-19
C5041 a_5188_2223# a_5779_4943# 0.042641f
C5042 a_619_3677# a_975_3677# 0.008475f
C5043 a_4575_2223# a_4268_2767# 0.012139f
C5044 a_4728_4399# a_1823_4943# 2.51e-19
C5045 a_2375_4399# a_5779_4943# 0.239535f
C5046 a_4751_1831# a_1865_4013# 0.177068f
C5047 a_3609_4399# a_5821_5101# 7.92e-20
C5048 a1 a_4115_5487# 0.002502f
C5049 a_2235_1256# a_1865_749# 0.005037f
C5050 a_4073_4625# a_4399_4943# 2.6e-19
C5051 a_3799_4118# a_3072_4399# 0.155518f
C5052 a_3240_3311# a_2249_3543# 1.05e-19
C5053 a_2235_1256# a_1823_3855# 0.006428f
C5054 a_3983_4520# a_5653_5095# 5e-20
C5055 a4 a_1125_3855# 9.42e-21
C5056 a_1697_743# a_1733_591# 4.78e-19
C5057 a_2045_2223# a_1508_1135# 4.67e-20
C5058 a_627_5487# a_2157_5719# 0.099461f
C5059 a_3537_6807# a_3573_6941# 6e-20
C5060 a_1037_4625# a_1508_1135# 0.20872f
C5061 a_2723_5487# a_2283_5487# 0.003858f
C5062 a_3076_5487# a_2235_5608# 3.98e-19
C5063 a_3537_1367# a_1775_4118# 1.23e-19
C5064 a5 a_4023_3677# 0.0032f
C5065 a_1421_2919# a_2367_1501# 2.21e-21
C5066 a_984_6183# a_317_5095# 0.001034f
C5067 a_2235_1256# a_4023_3311# 1.23e-22
C5068 a4 a_2235_1256# 1.37e-19
C5069 a_1125_3017# a_2412_3133# 4.51e-19
C5070 a_3072_3311# a_1823_4943# 0.027115f
C5071 DVDD a_4575_2223# 0.163891f
C5072 a_1455_6031# a_2157_5719# 0.033535f
C5073 a_5135_6031# a_2520_6575# 0.187435f
C5074 DVDD a_5863_4943# 0.00141f
C5075 a_2263_4943# a_1823_4943# 0.034978f
C5076 a_3387_6031# a_627_5487# 0.007164f
C5077 a_4457_743# a_5413_3133# 8.53e-21
C5078 a3 a_2616_5309# 6.26e-20
C5079 a_5009_6183# a_3537_6807# 4.19e-19
C5080 a_984_6183# a_1079_4765# 1.27e-20
C5081 a_685_1367# a_297_4105# 0.016785f
C5082 a_2249_4631# a_2520_3855# 1.64e-19
C5083 a_4364_2767# a_3571_2767# 3.73e-20
C5084 a_1784_1679# a_3148_1501# 7.66e-19
C5085 a_883_5309# a_443_4943# 0.005083f
C5086 a_4436_2767# a_3164_2223# 1.46e-19
C5087 a_3655_2767# a_1125_3017# 1.82e-20
C5088 a_3164_2223# a_4471_4399# 1.1e-20
C5089 a_4023_3311# a_3072_4399# 4.28e-20
C5090 a_5135_6031# b4 2.01e-19
C5091 a_1125_3017# a_409_3543# 0.00573f
C5092 a_2243_1929# a_1784_1679# 0.063408f
C5093 b0 a_3983_5608# 3.22e-19
C5094 a_4839_5309# a_5192_5309# 2.18e-19
C5095 a_3072_4399# a_5219_6031# 3.94e-21
C5096 a_2325_5713# a_3471_6031# 4.42e-20
C5097 a_1455_6031# a_3387_6031# 0.260684f
C5098 a_849_4105# a_2263_4221# 8.83e-19
C5099 b5 a_409_3543# 0.0025f
C5100 a_1775_854# a_1907_957# 0.033277f
C5101 a_685_1367# a_849_3017# 4.74e-20
C5102 a_883_2589# a_1039_1942# 1.08e-19
C5103 a_5943_2767# a_3663_1135# 4.53e-19
C5104 DVDD a_1769_2543# 8.72e-20
C5105 a5 a_2467_2223# 0.006612f
C5106 a_3813_3543# a_4533_2449# 0.008551f
C5107 a_2327_3432# a_2459_4399# 2.97e-20
C5108 a_3523_3030# a_4287_3855# 8.53e-21
C5109 a_2467_2223# a_3747_1135# 9.35e-20
C5110 a1 a_2249_4631# 0.112175f
C5111 a5 a_995_4399# 0.082363f
C5112 a_501_5719# a_947_4520# 2.96e-19
C5113 a0 a_5545_2925# 1.29e-19
C5114 a_3260_2589# a_2341_2455# 3.38e-19
C5115 a_297_3017# a_2249_3543# 5.43e-20
C5116 DVDD a_4824_5853# 8.89e-20
C5117 a_259_1831# a_1775_4118# 0.003203f
C5118 b3 a_2341_2455# 0.001081f
C5119 a_485_749# a_3663_1135# 4.33e-21
C5120 b2 a_6412_4007# 2.29e-20
C5121 a_2263_3855# a_2688_3855# 8.12e-20
C5122 a_3261_6183# P3 0.060929f
C5123 a_3813_3543# a_3849_3677# 6.46e-20
C5124 a_2375_3311# a_4023_3677# 4.98e-20
C5125 a_3655_2767# a_4268_2767# 2.9e-19
C5126 b3 a_553_1679# 1.8e-19
C5127 b0 a_1329_6183# 0.122434f
C5128 a_5943_2767# a_6368_2767# 8.12e-20
C5129 a_485_749# a_2367_1135# 1.26e-19
C5130 a1 a_2723_5853# 0.003018f
C5131 DVDD a_2412_3133# 4.72e-19
C5132 a_3983_4520# a_3240_4765# 3.05e-20
C5133 a_3609_4399# a_3609_4719# 0.009374f
C5134 a_2375_4399# a_3941_4765# 7.69e-20
C5135 a_2249_4631# a_4115_4765# 0.005502f
C5136 a_1039_1942# a_1907_957# 6.05e-20
C5137 a_5284_2223# a_5188_2223# 0.004869f
C5138 DVDD a_2263_5309# 0.150609f
C5139 a_883_4943# a_317_5095# 0.044609f
C5140 b2 a_1421_2919# 0.018228f
C5141 a_947_4520# a_1860_4765# 6.11e-20
C5142 a_4943_1653# a_1775_854# 0.094793f
C5143 b1 a_3072_4399# 0.106031f
C5144 a5 a_1769_3631# 1.32e-19
C5145 a_5135_6031# a_4031_5487# 0.30288f
C5146 a_4535_854# a_6412_4007# 0.021688f
C5147 a_5009_6183# a_6412_5719# 0.002635f
C5148 b2 a_443_4943# 0.002607f
C5149 b3 a_317_5095# 0.014685f
C5150 a_4751_1831# a_1697_743# 0.102781f
C5151 DVDD a_6277_4719# 1.65e-19
C5152 DVDD a_3655_2767# 0.001386f
C5153 a_4287_4221# a_1823_4943# 0.004605f
C5154 a_3387_6031# b5 0.001081f
C5155 a_4625_749# a_5923_1135# 8.63e-19
C5156 a_3571_2767# a_4528_1501# 2.57e-20
C5157 a_3517_5487# a_4471_5853# 1.52e-19
C5158 a1 a_4180_6031# 1.97e-19
C5159 a_3537_1367# a_317_743# 0.001578f
C5160 DVDD a_409_3543# 1.27025f
C5161 a_3891_3432# a_1823_4943# 0.365247f
C5162 a_1308_2223# a_2045_2223# 3.02e-21
C5163 a_4401_2223# a_1865_4013# 3.19e-20
C5164 a0 a_1435_4765# 0.003406f
C5165 a_5081_2767# a_2341_2455# 2.19e-19
C5166 a_5075_1148# a_5289_1433# 0.072192f
C5167 a1 a_1435_4399# 0.003716f
C5168 a3 a_317_2455# 3.99e-19
C5169 b3 a_1079_4765# 0.036381f
C5170 a_2375_4399# a_2327_4520# 0.189913f
C5171 a_2249_4631# a_2417_4625# 0.523625f
C5172 b0 a_1037_4625# 0.004621f
C5173 a3 a_248_4631# 0.103287f
C5174 a_4268_2767# a_3663_1135# 0.001468f
C5175 a_2375_3311# a_2467_2223# 0.001518f
C5176 a_2327_3432# a_1775_854# 7.38e-22
C5177 a_849_3017# a_1692_4399# 1.29e-20
C5178 a_6173_2543# a_3663_1135# 1.35e-19
C5179 a_2375_3311# a_995_4399# 1.31e-19
C5180 a4 a_2815_4765# 8.09e-21
C5181 a_2520_6575# a_1775_6696# 0.166529f
C5182 a_2235_1256# a_3471_1679# 0.059167f
C5183 a_3523_3030# a_3537_1367# 6.98e-19
C5184 a_395_2344# a_1171_1679# 4.46e-20
C5185 P7 a_2980_1135# 0.060496f
C5186 DVDD a_2157_5719# 0.976926f
C5187 a2 a_5227_3855# 0.034315f
C5188 a_849_4105# a_2327_4520# 1.11e-19
C5189 a_2249_4631# a_2367_5487# 1.91e-20
C5190 a_4073_4625# a_4351_5206# 0.008234f
C5191 a_1823_6575# a_1775_6696# 0.274919f
C5192 a_2377_2589# a_849_4105# 6.76e-21
C5193 a_961_1831# a_395_854# 1.58e-19
C5194 a_5376_591# a_2980_1135# 9.49e-19
C5195 a_1125_3017# a_1631_3133# 0.039773f
C5196 a_997_2045# a_317_2455# 2.7e-20
C5197 a_2327_3432# a_573_4105# 0.001126f
C5198 a_469_1929# a_355_1653# 0.01872f
C5199 a_2417_4625# a_2723_5853# 3.88e-21
C5200 a_3072_4399# a_5779_4943# 0.001596f
C5201 a_317_5095# a_527_5309# 0.012047f
C5202 a_2616_4943# P5 0.005587f
C5203 a_4399_4943# a_5821_5101# 0.690788f
C5204 a_763_1256# a_1784_1679# 0.049531f
C5205 DVDD a_3663_1135# 1.2795f
C5206 a_501_5719# a_2320_6031# 0.008102f
C5207 a_6403_2045# a_5779_4943# 0.015478f
C5208 a_1508_1135# a_1775_4118# 0.83712f
C5209 b2 a_2689_6031# 9.78e-20
C5210 a_5009_6183# a_6572_5309# 1.71e-20
C5211 a_2520_3855# a_3148_1501# 3.13e-19
C5212 a_2235_1256# a_2493_1929# 0.003355f
C5213 a_3387_6031# DVDD 1.68081f
C5214 a_2327_3432# a_1039_1942# 1.41e-19
C5215 a_2243_1929# a_2520_3855# 0.004649f
C5216 DVDD a_2367_1135# 0.251478f
C5217 a_259_1831# a_317_743# 0.0041f
C5218 a_2375_3311# a_1769_3631# 1.97e-20
C5219 DVDD a_4103_1501# 0.046259f
C5220 a5 a_2341_2455# 0.097675f
C5221 a_353_2223# a_317_2455# 2.74e-20
C5222 b3 a_3471_6031# 0.001052f
C5223 a_4073_4625# a_5541_4719# 0.009374f
C5224 a0 a_1079_4399# 0.009942f
C5225 P3 a_4351_5206# 1.22e-20
C5226 a_2244_2767# a_1865_749# 1.9e-19
C5227 DVDD a_6368_2767# 3.76e-19
C5228 a_2244_2767# a_1823_3855# 0.443111f
C5229 b2 a_3240_3677# 3.19e-20
C5230 a_2520_3855# a_1823_4943# 0.013564f
C5231 a_627_5487# a_3517_5487# 0.05599f
C5232 a_2045_2223# a_685_1367# 6.59e-20
C5233 b1 a_2815_4765# 0.001154f
C5234 a_355_1653# a_1236_2589# 2.93e-20
C5235 a5 a_553_1679# 0.004302f
C5236 a_1539_6397# a_1329_6183# 0.019166f
C5237 a_5137_4221# a_1692_4399# 5.12e-20
C5238 a_4943_1653# a_4931_2589# 5.97e-19
C5239 a_1907_3855# a_1823_3855# 0.059224f
C5240 a_6020_4221# a_5227_3855# 4.35e-21
C5241 a_1860_4399# a_1692_4399# 0.007759f
C5242 a_5943_3133# a_5227_3855# 0.013745f
C5243 a_1455_6031# a_3517_5487# 0.029655f
C5244 a4 a_2244_2767# 0.029979f
C5245 a_5311_3855# a_5227_3855# 0.073528f
C5246 a_501_5719# a_2325_5713# 0.014912f
C5247 DVDD a_4456_1135# 3.47e-19
C5248 a_763_1256# a_975_3311# 6.31e-21
C5249 a1 a_1823_4943# 0.250064f
C5250 DVDD a_1631_3133# 0.154463f
C5251 a5 a_317_5095# 0.00941f
C5252 a_4457_743# a_2341_2455# 3.17e-20
C5253 a_4943_1653# a_5545_2925# 4.96e-19
C5254 a2 a_2320_6031# 4.55e-19
C5255 b0 a_5192_5309# 6.95e-20
C5256 a_1421_2919# a_2459_4399# 1.02e-20
C5257 a4 a_1907_3855# 4.05e-20
C5258 a_4401_2223# a_1697_743# 2.3e-20
C5259 DVDD a_975_3677# 0.046154f
C5260 a2 a_4640_4221# 4.04e-20
C5261 a4 a_6092_3855# 5.54e-20
C5262 a_1784_1679# a_1987_3133# 2.21e-21
C5263 a_4268_2767# a_4436_3133# 0.007578f
C5264 a_1329_6183# a_1692_4399# 9.94e-21
C5265 a_3261_6183# a_3747_6575# 0.013507f
C5266 a_4943_1653# a_5923_1135# 4.89e-21
C5267 a_4457_743# a_2980_1135# 0.131525f
C5268 P8 a_4709_1929# 5.56e-20
C5269 a_3387_6031# a_3983_4520# 6.06e-21
C5270 a_6005_1135# a_2980_1135# 0.001004f
C5271 a_1455_6031# a_3799_4118# 1e-20
C5272 a_757_6281# a_2249_4631# 0.024206f
C5273 a_5135_6031# a_2375_4399# 1.25e-19
C5274 a_395_854# a_443_591# 0.140037f
C5275 a_2980_5487# a_4073_4625# 3.99e-21
C5276 b2 a_3537_1367# 6.32e-20
C5277 a5 a_573_3855# 7.6e-19
C5278 a_2375_3311# a_2341_2455# 0.008339f
C5279 a_6219_4943# a_4399_4943# 0.005779f
C5280 a_501_5719# a_984_6183# 0.168399f
C5281 a_5863_4943# a_5653_5095# 0.050146f
C5282 a_5264_4943# a_5779_4943# 4.35e-20
C5283 b4 a_3847_3855# 0.062522f
C5284 DVDD a_4436_3133# 6.71e-19
C5285 a_2551_2589# a_2243_1929# 1.82e-20
C5286 a_1508_1135# a_317_743# 0.00683f
C5287 b1 a_2244_2767# 2.49e-20
C5288 a_4103_6941# a_2283_5487# 6.52e-21
C5289 a_3537_1367# a_4535_854# 0.002171f
C5290 a_2325_5713# a2 0.052478f
C5291 a_1775_854# a_6412_4007# 5.24e-20
C5292 a_1037_4625# a_1692_4399# 0.066001f
C5293 b0 a_1775_4118# 2.11e-20
C5294 a_995_4399# a_297_4105# 3.17e-21
C5295 a_2327_4520# a_3072_4399# 0.07709f
C5296 b4 a_961_1831# 0.036095f
C5297 a_2417_4625# a_1823_4943# 0.013184f
C5298 b2 a_1328_3677# 4.77e-19
C5299 a_2551_2589# a_1823_4943# 2.77e-21
C5300 a_5837_1831# a_4544_3855# 0.15232f
C5301 a_961_1831# a_1251_1135# 3.81e-20
C5302 a_2467_2223# a_849_3017# 0.001004f
C5303 a_1775_854# a_1421_2919# 2.81e-20
C5304 a_4709_1929# a_5503_2767# 1.22e-20
C5305 a_409_3543# a_2249_3543# 0.003415f
C5306 a_5667_3855# a_4544_3855# 1.48e-19
C5307 a_297_3017# a_409_3543# 1.04208f
C5308 a_5821_5101# a_4351_5206# 5.12e-20
C5309 a_1823_4943# a_2367_5487# 5.98e-19
C5310 a_485_749# a_1865_749# 0.214773f
C5311 a_317_743# a_527_957# 0.011205f
C5312 a_995_4399# a_849_3017# 7.58e-20
C5313 a_6296_3133# a_3891_3432# 8.45e-20
C5314 b5 a_3799_4118# 0.018358f
C5315 a_757_6281# a_1435_4399# 0.011819f
C5316 a_1823_3855# a_485_749# 2.73e-19
C5317 a_3891_3432# a_6020_3855# 1.33e-19
C5318 a5 a_219_1929# 0.002262f
C5319 a4 a_5943_2767# 0.001341f
C5320 a1 a_2459_4765# 0.002693f
C5321 a_1775_4118# a_2193_1501# 0.006958f
C5322 a_1508_1135# a_2367_1501# 2.53e-19
C5323 a_1125_3017# a_1865_749# 1.28e-20
C5324 a_3571_2767# a_3847_3855# 0.03028f
C5325 a_481_6281# b0 0.142681f
C5326 a_4804_3677# a_4544_3855# 4.77e-19
C5327 a_1125_3017# a_1823_3855# 0.051875f
C5328 a_1421_2919# a_573_4105# 0.466176f
C5329 a_984_6183# a2 7.83e-19
C5330 a_259_1831# a_895_1135# 0.030246f
C5331 a_573_4105# a_443_4943# 0.002259f
C5332 a_3847_3855# a_4031_5487# 8.37e-20
C5333 a3 a_3072_3311# 1.08e-20
C5334 a_2263_6575# a0 7.6e-19
C5335 a_2244_2767# a_3471_1679# 0.04028f
C5336 b5 a_1823_3855# 0.052014f
C5337 a3 a_2263_4943# 0.037841f
C5338 a_2248_6031# a_1823_6575# 1.91e-19
C5339 b1 a_627_5487# 0.482538f
C5340 DVDD a_3517_5487# 0.481238f
C5341 a_1421_2919# a_1039_1942# 0.710689f
C5342 a_3799_4118# a_4268_2767# 1.08e-19
C5343 a_1692_4399# a_905_4399# 1.27e-20
C5344 a_4115_4399# a_3072_4399# 0.024877f
C5345 a4 a_1125_3017# 0.143258f
C5346 a_2325_5713# a_2815_4399# 2.13e-19
C5347 a_6092_3855# a_5779_4943# 5.18e-19
C5348 a_501_5719# b3 1.84e-20
C5349 b5 a4 0.177081f
C5350 a_1455_6031# a_1539_6031# 0.059152f
C5351 b4 a_4544_3855# 0.469444f
C5352 a_1497_6189# a_1895_6031# 0.052711f
C5353 a5 a_4636_3311# 0.154998f
C5354 a_443_4943# a_2283_5487# 1.59e-19
C5355 a_1455_6031# b1 0.05678f
C5356 a_685_1367# a_1775_4118# 0.001066f
C5357 a_4268_2767# a_1865_749# 4.81e-20
C5358 a_2493_1929# a_2244_2767# 0.020201f
C5359 b2 a_3148_5487# 1.57e-20
C5360 a_4364_3133# a_1865_4013# 1.62e-19
C5361 a_4011_3133# a_3072_3311# 1.85e-19
C5362 b2 a_1400_3311# 1.96e-20
C5363 a_3983_5608# a_995_4399# 3.92e-22
C5364 a_1329_6183# a_1733_6941# 1.73e-19
C5365 a_1697_743# a_6828_1679# 1.84e-20
C5366 DVDD a_3799_4118# 0.822646f
C5367 a_4847_1653# a_3663_1135# 0.006692f
C5368 a1 a_4115_5853# 0.006846f
C5369 a_763_1256# a_883_2223# 2.82e-21
C5370 DVDD a_2493_1679# 2.61e-20
C5371 a_4533_2449# a_2467_2223# 2.69e-21
C5372 a_4533_2449# a_995_4399# 1.29e-20
C5373 a_2815_4765# a_2327_4520# 0.010875f
C5374 a_2325_5713# a_2263_6941# 9.12e-22
C5375 a_2459_4765# a_2417_4625# 0.033252f
C5376 a_5413_2767# a_4544_3855# 4.78e-19
C5377 a0 a_2285_4765# 1.45e-19
C5378 P9 a_1308_957# 0.007578f
C5379 a_1308_2223# a_317_743# 4.17e-21
C5380 a_5227_3855# a_5863_5309# 1.45e-20
C5381 b3 a_1860_4765# 9.83e-19
C5382 a_2235_1256# a_3076_1135# 4.95e-20
C5383 a_5356_2589# a_3847_3855# 2.57e-20
C5384 a4 a_4268_2767# 0.032297f
C5385 a0 a_4839_4943# 0.004349f
C5386 DVDD a_1865_749# 1.63108f
C5387 a_6756_1679# a_5779_4943# 7.33e-20
C5388 DVDD a_1823_3855# 0.593107f
C5389 a_4457_743# a_4636_3311# 3.68e-20
C5390 a_1697_743# a_3747_1501# 0.00413f
C5391 a_501_5719# a_527_5309# 1.04e-19
C5392 DVDD a_1907_4943# 0.001386f
C5393 a_1775_4118# a_2263_957# 2.29e-19
C5394 a_317_2455# a_721_1501# 5.6e-19
C5395 b2 a_1508_1135# 0.371902f
C5396 a3 a_527_4943# 8.37e-20
C5397 a_5545_2925# a_6412_4007# 4.12e-19
C5398 b1 a_1125_3017# 8.58e-20
C5399 a_757_6281# a_1823_4943# 1.48e-19
C5400 a_3387_6031# a_5653_5095# 6.01e-20
C5401 a_5009_6183# a_4399_4943# 0.212651f
C5402 a_5135_6031# a_3072_4399# 2.49e-20
C5403 a_6047_2045# a_2980_1135# 1.61e-19
C5404 a_3983_5608# a_2235_5608# 0.058877f
C5405 a_995_4399# a_1329_6183# 2.91e-20
C5406 a_4535_854# a_5075_1148# 0.004905f
C5407 a1 a_3240_4399# 4.22e-20
C5408 b1 b5 0.342586f
C5409 DVDD a4 1.36679f
C5410 b0 P1 6.87e-20
C5411 a0 P5 0.008545f
C5412 a_2781_2767# a_1039_1942# 9.63e-21
C5413 DVDD a_4023_3311# 0.27116f
C5414 a2 b3 0.29381f
C5415 a_4544_3855# a_4031_5487# 0.002102f
C5416 a_3164_2223# a_3931_3855# 4.47e-21
C5417 a_5137_4221# a_2235_5608# 1.36e-21
C5418 a_5503_2767# a_3891_3432# 0.015535f
C5419 DVDD a_5219_6031# 0.04232f
C5420 a_553_1679# a_297_4105# 7.01e-20
C5421 a_4625_749# a_395_854# 2.96e-20
C5422 a_317_743# a_2193_1501# 1.05e-19
C5423 a_1775_854# a_4709_1679# 3.76e-19
C5424 a_4287_3855# a_2283_5487# 1.82e-20
C5425 a_3891_3432# a_6412_5719# 1.46e-19
C5426 a_395_2344# a_619_3677# 0.06612f
C5427 a_3813_3543# a_3523_3030# 0.705768f
C5428 a_5943_2767# a_5779_4943# 0.008585f
C5429 a_297_3017# a_975_3677# 0.005557f
C5430 a_849_3017# a_2341_2455# 0.001187f
C5431 b5 a_3241_3855# 7.29e-20
C5432 a_6572_4943# a_5821_5101# 3.5e-19
C5433 a2 a_3076_5487# 1.41e-19
C5434 a_6644_4943# a_5653_5095# 7.66e-19
C5435 a_4456_6575# a_3537_6807# 1.44e-19
C5436 a_4103_6575# a_627_5487# 0.013745f
C5437 a3 a_975_3311# 0.009825f
C5438 a_627_5487# a_711_5487# 0.030161f
C5439 a_1775_4118# a_1692_4399# 0.003184f
C5440 DVDD a_1527_2045# 0.144826f
C5441 a_4528_6575# b4 9.69e-20
C5442 a_1539_6397# a_481_6281# 0.02892f
C5443 a_553_1679# a_849_3017# 5.6e-19
C5444 a_3571_2767# a_443_591# 0.003211f
C5445 a_297_4105# a_317_5095# 7.89e-20
C5446 a_3609_4399# a_4728_4399# 0.132188f
C5447 a_627_5487# a_711_5853# 0.060052f
C5448 a_2045_2223# a_2467_2223# 0.226701f
C5449 a_3983_4520# a_3799_4118# 0.481905f
C5450 a_1455_6031# a_4103_6575# 2.8e-19
C5451 a_5009_6183# a_3261_6183# 0.003886f
C5452 a_2980_5487# a_3747_6575# 5.57e-19
C5453 b2 a_1492_5487# 2.13e-20
C5454 a_3537_1367# a_1775_854# 0.158226f
C5455 a_1329_6183# a_2235_5608# 1.43e-19
C5456 a_947_4520# a_2249_4631# 3.06e-19
C5457 a_4180_2045# a_2467_2223# 3.03e-19
C5458 a_4351_5206# a_4896_5853# 0.008482f
C5459 a1 a_3537_6807# 0.050215f
C5460 a_1037_4625# a_995_4399# 0.385575f
C5461 a_501_5719# a_1420_5853# 2.54e-19
C5462 b2 a_1492_5853# 4.86e-21
C5463 a_2244_2767# a_2327_4520# 2.78e-20
C5464 a_4667_591# a_1865_4013# 1.45e-19
C5465 a_685_1367# a_317_743# 0.013908f
C5466 a_3571_2767# a_4180_1679# 1.59e-19
C5467 a_4011_3133# a_3891_3432# 5.51e-19
C5468 a0 a_1236_5309# 2.57e-19
C5469 b0 a_883_5309# 1.36e-19
C5470 a_501_5719# a5 0.001275f
C5471 a_5188_2223# a_3847_3855# 0.075777f
C5472 b5 a_5779_4943# 0.027392f
C5473 a_3609_4399# a_3072_3311# 9.1e-20
C5474 a2 a_4896_4399# 8.47e-20
C5475 a_4073_4625# a_1865_4013# 2.37e-19
C5476 a_2375_4399# a_3847_3855# 4.54e-20
C5477 a_2249_4631# a_5227_3855# 1.03e-19
C5478 DVDD a_1539_6031# 0.001386f
C5479 a_1497_6189# a1 5.82e-19
C5480 a_573_4105# a_297_3855# 5.9e-21
C5481 a_297_4105# a_573_3855# 1.03e-19
C5482 a_481_6281# a_1692_4399# 3.52e-21
C5483 a_3240_4399# a_2417_4625# 1.01e-19
C5484 a_4575_2589# a_4533_2449# 0.033252f
C5485 P2 a_1365_6031# 1.33e-19
C5486 DVDD b1 2.02152f
C5487 a_2493_1929# a_485_749# 1.41e-20
C5488 a0 a_5667_3855# 1.34e-19
C5489 DVDD a_3931_4221# 0.161939f
C5490 a_3847_3855# a_849_4105# 1.53e-20
C5491 b3 a_1236_2589# 0.001188f
C5492 b5 a_527_2589# 1.43e-19
C5493 a_1435_4765# a_443_4943# 3.93e-20
C5494 b4 a_4471_4765# 0.009263f
C5495 a_1692_4399# a_1861_5807# 2.13e-20
C5496 a4 a_3983_4520# 6.7e-21
C5497 a_2493_1929# a_1125_3017# 0.001133f
C5498 a_1769_3631# a_1037_4625# 0.010091f
C5499 a_2980_5487# a_3609_4719# 7.98e-23
C5500 a_4533_2449# a_2341_2455# 0.015661f
C5501 a_5448_957# a_443_591# 8.59e-21
C5502 a_961_1831# a_1171_1679# 0.04028f
C5503 a_4268_2767# a_5779_4943# 8.27e-19
C5504 a3 a_2520_3855# 1.58e-20
C5505 a_6173_2543# a_5779_4943# 5.99e-19
C5506 a_5837_1831# a_4625_749# 0.806419f
C5507 a_1907_957# a_395_854# 0.040101f
C5508 a_2263_957# a_317_743# 0.002553f
C5509 b5 a_2263_4221# 0.002106f
C5510 a_961_1831# a_849_4105# 1.79e-20
C5511 a_3387_6031# a_5863_4943# 9e-21
C5512 a_5009_6183# a_5689_4943# 7.56e-20
C5513 a0 a_2520_6575# 6.26e-19
C5514 a_3168_3311# a_3072_3311# 0.004869f
C5515 a_947_4520# a_1435_4399# 0.021244f
C5516 a2 a_1420_5487# 9.5e-21
C5517 a_995_4399# a_905_4399# 0.006823f
C5518 a_259_1831# a_1775_854# 4.87e-19
C5519 a_1784_1679# a_1527_1679# 0.024423f
C5520 a0 a_1823_6575# 0.21158f
C5521 a1 a_5503_2767# 4.76e-20
C5522 a_259_1831# a_997_1679# 3.07e-19
C5523 a3 a1 0.091711f
C5524 a2 a5 0.036403f
C5525 DVDD a_5779_4943# 1.73815f
C5526 b0 b2 0.00145f
C5527 a0 b4 0.250883f
C5528 a1 a_6412_5719# 0.007597f
C5529 a_1895_6397# b0 0.002024f
C5530 a_6219_4943# a_6572_4943# 2.18e-19
C5531 DVDD a_3471_1679# 0.001386f
C5532 a_2285_4399# a_1775_4118# 3.56e-20
C5533 a_219_1929# a_297_4105# 0.019817f
C5534 a_259_1831# a_573_4105# 1.09e-19
C5535 b2 a_3813_3543# 0.075158f
C5536 a_2341_2455# a_4793_1679# 7.08e-20
C5537 DVDD a_527_2589# 0.001395f
C5538 a_2157_5719# a_2263_5309# 5.72e-19
C5539 a_4625_749# a_6047_1679# 0.095121f
C5540 b1 a_3983_4520# 2.38e-19
C5541 a_259_1831# a_1039_1942# 0.012148f
C5542 a_5188_2223# a_4544_3855# 0.0079f
C5543 a_5009_6183# a_4351_5206# 0.088602f
C5544 b0 a_4535_854# 3.31e-21
C5545 a_883_591# a_395_854# 0.005557f
C5546 a_1236_591# a_317_743# 8.05e-19
C5547 a_527_591# a_485_749# 0.033252f
C5548 a_1308_2589# a_317_2455# 3.15e-19
C5549 a5 a_469_1929# 0.001737f
C5550 a_1079_4399# a_443_4943# 6.8e-20
C5551 a_4073_4625# a_3757_4221# 1.65e-20
C5552 a_3983_4520# a_3931_4221# 1.47e-19
C5553 a_3799_4118# a_2249_3543# 5.42e-21
C5554 a_2375_4399# a_4544_3855# 6.91e-19
C5555 a_5923_2223# a_3891_3432# 0.001367f
C5556 P9 a_1697_743# 0.001971f
C5557 a_3813_3543# a_4535_854# 0.009117f
C5558 a_2688_6575# a_1775_6696# 2.43e-19
C5559 DVDD a_2493_1929# 0.259464f
C5560 a_5284_2223# b5 5.21e-20
C5561 a_3609_4399# a_3891_3432# 6.19e-20
C5562 a1 a_4011_3133# 2.57e-21
C5563 DVDD a_2263_4221# 0.144605f
C5564 a_2045_2223# a_2341_2455# 0.808726f
C5565 a_1329_6183# a_317_5095# 2.98e-19
C5566 a_3523_3030# a_1692_4399# 5.62e-20
C5567 a_4103_6575# DVDD 0.225519f
C5568 a2 a_4457_743# 9e-21
C5569 a_4180_2045# a_2341_2455# 8.88e-20
C5570 DVDD a_711_5487# 0.160669f
C5571 a_3655_2767# a_3663_1135# 7.92e-20
C5572 a_757_6281# a_1308_5309# 1.5e-19
C5573 b1 a_1308_4943# 4.44e-19
C5574 a_395_2344# a_485_749# 1.89e-21
C5575 a_2249_3543# a_1823_3855# 0.031982f
C5576 a_553_1679# a_2045_2223# 0.004305f
C5577 a_1697_743# a_1952_1679# 8.18e-20
C5578 a_5095_1929# a_5587_2767# 3.95e-20
C5579 a_4751_1831# a_4709_1929# 0.147358f
C5580 a_1775_854# a_5075_1148# 0.002402f
C5581 a_2045_2223# a_2980_1135# 1.79e-20
C5582 DVDD a_711_5853# 0.001386f
C5583 a1 a_6572_5309# 5.69e-20
C5584 b4 a_4824_4399# 2.88e-19
C5585 a_3260_2589# a_3164_2223# 0.005587f
C5586 a_2616_3855# a_1823_3855# 3.87e-19
C5587 b3 a_3164_2223# 1.44e-20
C5588 a_763_1256# a_1251_1501# 0.008305f
C5589 a_4483_5309# a_3905_5719# 1.1e-19
C5590 a0 a_4031_5487# 0.499389f
C5591 a_4839_5309# a_2283_5487# 0.118613f
C5592 a3 a_2417_4625# 0.004036f
C5593 a_395_2344# a_1125_3017# 1.02e-19
C5594 a_1455_6031# a_4115_4399# 4.56e-21
C5595 a_3537_1367# a_5923_1135# 1.44e-20
C5596 a5 a_5311_3855# 0.005677f
C5597 b5 a_2327_4520# 3.77e-19
C5598 b3 a_3905_5719# 0.078347f
C5599 b4 a_883_2589# 0.001087f
C5600 a5 a_1236_2589# 1.38e-19
C5601 a2 a_2375_3311# 1.29e-19
C5602 a_4073_4625# a_5821_5101# 0.003491f
C5603 a_1697_743# a_1865_4013# 0.11167f
C5604 a_3799_4118# a_5653_5095# 4.25e-21
C5605 a_4847_1653# a_1865_749# 1.51e-21
C5606 a_4728_4399# a_4399_4943# 0.010398f
C5607 a_2327_3432# P5 3.56e-20
C5608 a4 a_2249_3543# 9.73e-19
C5609 a_395_2344# b5 0.013184f
C5610 a_2467_2223# a_1775_4118# 0.026469f
C5611 a_297_3017# a4 0.200513f
C5612 a_1775_854# a_1508_1135# 0.002602f
C5613 a_2325_5713# a_2249_4631# 0.003696f
C5614 a_995_4399# a_1775_4118# 0.174523f
C5615 a_3573_6575# a_3517_5487# 4.66e-20
C5616 a_5265_5807# a_2235_5608# 0.009374f
C5617 a3 a_2367_5487# 9.41e-20
C5618 a_1037_4625# a_317_5095# 0.002833f
C5619 a_947_4520# a_1823_4943# 0.001512f
C5620 a_685_1367# a_895_1135# 0.011205f
C5621 a_2520_3855# a_2688_957# 4.77e-20
C5622 a5 a_4732_3677# 1.33e-19
C5623 a_5095_1929# a_5503_2767# 9.65e-20
C5624 a_573_4105# a_1508_1135# 0.03729f
C5625 a4 a_4847_1653# 0.002342f
C5626 a_5227_3855# a_1823_4943# 0.024966f
C5627 DVDD a_5284_2223# 2.76e-19
C5628 a_3072_3311# a_4399_4943# 3.67e-21
C5629 a_3847_3855# a_3072_4399# 1.39e-19
C5630 a_2980_5487# a_3573_6941# 4.18e-21
C5631 a_961_1831# a_2235_1256# 2.92e-19
C5632 a_3387_6031# a_2157_5719# 0.003923f
C5633 a_1037_4625# a_1079_4765# 0.033252f
C5634 a_2325_5713# a_2723_5853# 0.052636f
C5635 a_2688_4943# a_1823_4943# 2.48e-19
C5636 a_4943_1653# a_5837_1831# 0.021474f
C5637 DVDD a_527_591# 0.006168f
C5638 a_4457_743# a_5311_3855# 5.84e-20
C5639 a_1775_854# a_527_957# 1.38e-19
C5640 a_1039_1942# a_1508_1135# 0.44343f
C5641 a_481_6281# a_995_4399# 3.14e-19
C5642 a_4805_2767# a_3571_2767# 3.13e-20
C5643 a_1539_6397# b2 3.52e-19
C5644 a_1539_6397# a_1895_6397# 0.009846f
C5645 b0 a_5219_6397# 0.004303f
C5646 a_1631_3133# a_409_3543# 1.88e-20
C5647 a4 a_5653_5095# 0.468348f
C5648 a_1775_4118# a_2235_5608# 5.21e-20
C5649 a_4103_1501# a_3663_1135# 0.042149f
C5650 a_4896_5487# a_2235_5608# 2.74e-20
C5651 a_4399_4943# a_5575_6031# 6.4e-20
C5652 a_2980_5487# a_5009_6183# 7.99e-21
C5653 a_1497_6189# a_757_6281# 6.19e-21
C5654 a2 a_3471_6397# 3.31e-21
C5655 a_1455_6031# a_5135_6031# 1.11e-19
C5656 DVDD a_2327_4520# 0.802034f
C5657 a_975_3677# a_409_3543# 0.044609f
C5658 b1 a_2249_3543# 0.082838f
C5659 DVDD a_395_2344# 1.62837f
C5660 b1 a_297_3017# 0.011315f
C5661 a_1823_3855# a_1733_4221# 0.006823f
C5662 a_4636_3311# a_4533_2449# 5.96e-21
C5663 a_1865_4013# a_1907_4221# 0.089151f
C5664 a0 a_4471_5487# 0.00258f
C5665 a_4625_749# a_5448_957# 4.93e-19
C5666 a1 a_3609_4399# 0.057404f
C5667 a_2325_1929# a_1775_4118# 0.004073f
C5668 a_2244_2767# a_1631_2767# 2.9e-19
C5669 a_4401_2589# a_2341_2455# 2.33e-19
C5670 b3 a_4115_5487# 4.45e-19
C5671 DVDD a_2193_5487# 4.94e-19
C5672 a_3241_3855# a_2249_3543# 0.01004f
C5673 b2 a_1692_4399# 0.009852f
C5674 a_4456_1135# a_3663_1135# 1.16e-19
C5675 a_3523_3030# a_4023_3677# 0.06189f
C5676 a_3813_3543# a_4379_3677# 0.046848f
C5677 a_4364_2767# a_4268_2767# 0.005622f
C5678 a_481_6281# a_2235_5608# 2.66e-19
C5679 b0 a_1907_6941# 0.002946f
C5680 a_5173_3631# a_2341_2455# 0.009374f
C5681 a_2375_4399# a_4471_4765# 0.002231f
C5682 a1 a_3148_5853# 2.63e-19
C5683 a_2249_4631# a_4824_4765# 2.95e-19
C5684 a_3983_4520# a_3941_4765# 9.09e-20
C5685 a_3609_4399# a_4115_4765# 0.04028f
C5686 a_6005_2223# a_5188_2223# 7.19e-19
C5687 a_763_1256# a_355_1653# 0.006169f
C5688 a5 a_3164_2223# 3.3e-19
C5689 a_4535_854# a_1692_4399# 7.58e-20
C5690 a_3164_2223# a_3747_1135# 1.2e-20
C5691 a5 a_2459_3677# 0.00357f
C5692 a_2467_2223# a_317_743# 3.02e-19
C5693 b1 a_5653_5095# 1.45e-21
C5694 a_757_6281# a3 0.026645f
C5695 a_4640_4221# a_1823_4943# 5.02e-20
C5696 DVDD a_4115_4399# 0.156543f
C5697 a_1692_4399# a_1788_4765# 0.005587f
C5698 a_4544_3855# a_3072_4399# 2.67e-20
C5699 a_3517_5487# a_4824_5853# 2.72e-20
C5700 b4 a_2327_3432# 0.014142f
C5701 a_1865_4013# a_3609_4719# 4.86e-20
C5702 a1 a_4621_6031# 5.35e-21
C5703 a_4544_3855# a_6403_2045# 9.64e-21
C5704 a_3891_3432# a_4399_4943# 4.89e-20
C5705 a_4931_2223# a_1865_4013# 0.003424f
C5706 a_4751_1831# a_4860_1367# 0.059886f
C5707 a_2235_1256# a_443_591# 8.5e-20
C5708 a_2341_2455# a_1775_4118# 0.016338f
C5709 a_5289_1433# a_2980_1135# 5.6e-20
C5710 a_3891_3432# a_6756_2045# 2.08e-20
C5711 a_5075_1148# a_5923_1135# 0.06231f
C5712 a_1697_743# a_4493_957# 1.08e-20
C5713 a0 a_2375_4399# 0.165239f
C5714 a_3609_4399# a_2417_4625# 0.015574f
C5715 a_3983_4520# a_2327_4520# 1.49e-19
C5716 a_3523_3030# a_2467_2223# 9.56e-19
C5717 a_3813_3543# a_1775_854# 2.13e-20
C5718 a_297_3017# a_527_2589# 3.92e-19
C5719 a_4847_1653# a_5779_4943# 0.00865f
C5720 b3 a_2249_4631# 0.236797f
C5721 a_3523_3030# a_995_4399# 0.011926f
C5722 a_553_1679# a_1775_4118# 0.03804f
C5723 a_2688_6941# a_1775_6696# 4.48e-19
C5724 a_1697_743# a_3297_1679# 2.55e-19
C5725 a_4751_1831# a_3827_1679# 3.66e-20
C5726 a_2235_1256# a_4180_1679# 2.93e-20
C5727 a_1775_4118# a_2980_1135# 0.04926f
C5728 b1 a_1733_4221# 5.01e-20
C5729 b0 a_573_4105# 0.023497f
C5730 a0 a_849_4105# 0.024089f
C5731 a5 a_3481_3133# 5.84e-22
C5732 a_627_5487# a_1775_6696# 0.245933f
C5733 a_5863_4943# a4 3.21e-19
C5734 a_2907_2589# a_849_4105# 6.57e-21
C5735 a_4728_4399# a_4351_5206# 7.53e-19
C5736 a_2375_4399# a_2723_5487# 3.32e-20
C5737 a_4943_1653# a_4031_5487# 9.46e-22
C5738 a2 a_3517_4943# 8.72e-20
C5739 a_2249_3543# a_2263_4221# 8.78e-20
C5740 a_4625_749# a_5188_2223# 0.005474f
C5741 a_2045_2223# a_2723_1501# 4.66e-20
C5742 a_5653_5095# a_5779_4943# 0.850502f
C5743 a_1775_854# a_2193_1501# 3.46e-19
C5744 a_2325_5713# a_1823_4943# 4.1e-19
C5745 a_2263_3855# a_2520_3855# 0.023407f
C5746 a_6828_2045# a_5779_4943# 2.43e-19
C5747 a_1455_6031# a_1775_6696# 0.004892f
C5748 a_3072_3311# a_4351_5206# 2.73e-19
C5749 a_2235_1256# a_3471_2045# 0.030161f
C5750 a_2327_3432# a_3571_2767# 0.005242f
C5751 a_5135_6031# DVDD 0.727004f
C5752 b0 a_2283_5487# 0.00263f
C5753 a_2325_1929# a_317_743# 2.04e-19
C5754 a_2375_3311# a_3164_2223# 0.501567f
C5755 DVDD a_3076_1135# 9.25e-19
C5756 a_2327_3432# a_2815_3677# 0.006039f
C5757 a_2375_3311# a_2459_3677# 0.066185f
C5758 a_3813_3543# a_2283_5487# 1.2e-20
C5759 a_1435_4765# a_1508_1135# 7.5e-20
C5760 a_1697_743# a_1907_591# 0.04028f
C5761 a5 a_2285_3311# 3.43e-20
C5762 a_3983_4520# a_4115_4399# 0.030746f
C5763 a_3517_5487# a_2157_5719# 0.003451f
C5764 a_3609_4399# a_4471_4399# 0.011819f
C5765 a_1907_6575# a_1329_6183# 0.001227f
C5766 a_5837_1831# a_5873_2045# 5.12e-20
C5767 b2 a_4023_3677# 0.002448f
C5768 a_2412_3133# a_1823_3855# 1.63e-19
C5769 a_2244_2767# a_3847_3855# 2.48e-19
C5770 a_947_4520# a_1733_3855# 1.73e-19
C5771 a_301_1929# a_1039_1942# 9.42e-20
C5772 a_2688_4221# a_1823_4943# 2.34e-19
C5773 a_1775_854# a_685_1367# 4.85e-19
C5774 a_1125_3017# a_1631_2767# 6.78e-21
C5775 a_5413_3133# a_4535_854# 8.16e-20
C5776 b1 a_3240_4765# 3.99e-19
C5777 a_3747_6941# a_3537_6807# 0.04028f
C5778 a_481_6281# a_317_5095# 1.24e-20
C5779 a3 a_1987_2767# 1.7e-19
C5780 a3 a_1251_1501# 3.83e-20
C5781 a_5667_4221# a_1692_4399# 0.020194f
C5782 a_2459_4399# a_1692_4399# 0.006431f
C5783 a_4457_743# a_5284_2589# 1.35e-19
C5784 a_5587_3133# a_1692_4399# 1.7e-19
C5785 a_501_5719# a_1329_6183# 0.185054f
C5786 a_5837_1831# a_6412_4007# 0.470488f
C5787 a_5137_3855# a_1692_4399# 4.78e-19
C5788 a_6296_3133# a_5227_3855# 2.59e-19
C5789 a_3387_6031# a_3517_5487# 0.035085f
C5790 a_6020_3855# a_5227_3855# 2.93e-20
C5791 a_2375_3311# a_3481_3133# 7.36e-20
C5792 a_685_1367# a_573_4105# 4.05e-20
C5793 a_961_1831# a_2244_2767# 0.002363f
C5794 DVDD a_6173_1455# 0.001058f
C5795 a1 a_4399_4943# 0.023089f
C5796 a_1236_5309# a_443_4943# 4.35e-21
C5797 a2 a_3983_5608# 0.001364f
C5798 a_2341_2455# a_317_743# 8.21e-21
C5799 a_4931_2223# a_1697_743# 0.001437f
C5800 a_3655_2767# a4 0.004262f
C5801 a2 a_5137_4221# 5.82e-20
C5802 a2 a_4533_2449# 0.129126f
C5803 a4 a_409_3543# 0.082124f
C5804 a_4575_2589# a_3523_3030# 3.17e-20
C5805 a_685_1367# a_1039_1942# 0.043336f
C5806 a_1775_854# a_2263_957# 0.018169f
C5807 b2 a_2467_2223# 1.14e-19
C5808 a_3261_6183# a_4456_6575# 3.78e-19
C5809 a_2249_3543# a_2327_4520# 0.004792f
C5810 a_553_1679# a_317_743# 0.002037f
C5811 a_4535_854# a_4877_1679# 6.77e-19
C5812 P11 a_2045_2223# 0.001338f
C5813 a_501_5719# a_1037_4625# 1.6e-20
C5814 a_3387_6031# a_3799_4118# 1.19e-20
C5815 a_6173_1135# a_5923_1135# 0.025037f
C5816 a_5009_6183# a_4073_4625# 1.72e-21
C5817 a_317_743# a_2980_1135# 0.315998f
C5818 b0 a_5545_2925# 5.15e-19
C5819 a_4471_4765# a_3072_4399# 4.06e-19
C5820 b2 a_995_4399# 0.087098f
C5821 a5 a_2249_4631# 0.008569f
C5822 a_297_3017# a_395_2344# 0.334723f
C5823 a_2263_3855# a_2417_4625# 8.2e-20
C5824 a_3523_3030# a_2341_2455# 0.002354f
C5825 a_2375_3311# a_2285_3311# 0.006823f
C5826 a_1497_6189# a_947_4520# 6.9e-21
C5827 a_3813_3543# a_5545_2925# 1.88e-19
C5828 a_2327_3432# a_2459_3311# 0.020252f
C5829 a_1865_749# a_3663_1135# 0.034263f
C5830 a_4636_3311# a_5173_3631# 6.29e-19
C5831 a_6219_4943# a_5821_5101# 0.0461f
C5832 a_5863_4943# a_5779_4943# 0.069063f
C5833 a_3261_6183# a1 0.090791f
C5834 DVDD a_1631_2767# 0.004026f
C5835 a_3891_3432# a_4351_5206# 5.81e-20
C5836 a_2907_2589# a_2235_1256# 8.84e-22
C5837 a2 a_1329_6183# 0.211077f
C5838 a_3747_6941# a3 2.36e-19
C5839 a_1865_749# a_2367_1135# 4.26e-19
C5840 a_1823_3855# a_2367_1135# 2.44e-19
C5841 a_883_4943# a_1823_4943# 4.35e-21
C5842 a_1236_4943# a_317_5095# 5.43e-19
C5843 a_2341_2455# a_2367_1501# 2.08e-21
C5844 a4 a_3663_1135# 0.031496f
C5845 a_1823_6575# a_443_4943# 1.29e-19
C5846 b4 a_1421_2919# 0.022042f
C5847 a_995_4399# a_1788_4765# 1.48e-19
C5848 a_2340_2767# a_2244_2767# 0.00557f
C5849 a_2551_2223# a_2045_2223# 0.044528f
C5850 a_2377_2223# a_2467_2223# 0.006823f
C5851 a_4943_1653# a_5188_2223# 0.099457f
C5852 a_1865_4013# a_4456_1501# 8.87e-21
C5853 DVDD a_1775_6696# 0.946133f
C5854 a0 a_3072_4399# 0.102769f
C5855 a_4943_1653# a_2375_4399# 5.41e-22
C5856 b2 a_1769_3631# 2.32e-19
C5857 a_2417_4625# a_4399_4943# 0.002403f
C5858 b2 a_2235_5608# 0.065932f
C5859 P1 a_317_5095# 0.114346f
C5860 a_5587_2767# a_5227_3855# 0.017903f
C5861 b3 a_1823_4943# 0.024152f
C5862 a_4751_1831# a_5095_1929# 1.29e-19
C5863 a_248_4631# a_1865_4013# 2.25e-21
C5864 a_3537_1367# a_395_854# 9.24e-20
C5865 a_573_4105# a_1692_4399# 1.04e-20
C5866 a_553_1679# a_2367_1501# 0.001352f
C5867 a_5009_6183# a_5045_6031# 6.46e-20
C5868 a_5311_4221# a_5667_4221# 0.009846f
C5869 b1 a_409_3543# 2.12e-19
C5870 a_3387_6031# a_5219_6031# 0.01786f
C5871 a_6368_3133# a_4544_3855# 6.73e-20
C5872 a3 a_355_1653# 0.001538f
C5873 b5 a_573_4719# 4.66e-20
C5874 a_3891_3432# a_6737_3855# 0.010026f
C5875 a_4751_1831# a_4667_957# 4.26e-19
C5876 a3 a_947_4520# 0.099079f
C5877 a_2244_2767# a_443_591# 2.84e-20
C5878 a_1508_1135# a_3076_1501# 2.38e-20
C5879 a_1775_4118# a_2723_1501# 0.036295f
C5880 a_1039_1942# a_1692_4399# 7.99e-22
C5881 a_2375_3311# a_2249_4631# 1.08e-19
C5882 a_1784_1679# a_2193_1135# 5.12e-20
C5883 a_2327_3432# a_2375_4399# 6.56e-20
C5884 a_5503_2767# a_5227_3855# 0.135744f
C5885 a_4625_749# a_6403_2045# 0.003858f
C5886 a_1125_3017# a_3847_3855# 2.31e-20
C5887 a_1692_4399# a_2283_5487# 3.45e-19
C5888 b1 a_2157_5719# 0.011241f
C5889 a_6412_4007# a_4031_5487# 2.42e-19
C5890 a_3261_6183# a_2417_4625# 2.21e-19
C5891 a_2244_2767# a_4180_1679# 2.3e-19
C5892 a_5448_591# a_2980_1135# 0.001024f
C5893 b5 a_3847_3855# 0.054068f
C5894 a_961_1831# a_485_749# 1.61e-19
C5895 a_2327_3432# a_849_4105# 0.759278f
C5896 a3 a_2688_4943# 0.001148f
C5897 a_1171_2045# a_317_2455# 0.001493f
C5898 a_4103_1135# a_3747_1135# 0.009846f
C5899 b0 a_2367_5853# 2.24e-19
C5900 a_317_5095# a_883_5309# 0.011819f
C5901 a_1421_2919# a_3571_2767# 8.82e-20
C5902 a_6277_4719# a_5779_4943# 1.64e-19
C5903 a_4824_4399# a_3072_4399# 3.21e-20
C5904 a_4115_4399# a_5653_5095# 1.55e-21
C5905 a_4023_3677# a_4379_3677# 0.008475f
C5906 a_961_1831# a_1125_3017# 0.019742f
C5907 b4 a_4712_4221# 2.65e-19
C5908 a_1455_6031# a_2248_6031# 2.93e-20
C5909 a_3387_6031# b1 0.001782f
C5910 a_975_3677# a4 0.001687f
C5911 a_219_1929# a_317_743# 5.49e-19
C5912 a_259_1831# a_395_854# 0.002963f
C5913 b4 a_4287_3855# 0.002228f
C5914 a_2327_3432# a_2815_3311# 0.010408f
C5915 a_3471_2045# a_2244_2767# 0.011205f
C5916 a_4268_2767# a_3847_3855# 0.909434f
C5917 a_2244_2767# a_2616_4221# 1.35e-20
C5918 a_353_2223# a_355_1653# 0.006861f
C5919 a_527_2223# a_317_2455# 0.020459f
C5920 b2 a_2341_2455# 0.155395f
C5921 a_1329_6183# a_2263_6941# 2.02e-20
C5922 a_527_2589# a_409_3543# 1.15e-20
C5923 DVDD a_573_4719# 6.79e-20
C5924 b0 a_1079_4399# 0.001118f
C5925 a1 a_4351_5206# 0.019484f
C5926 DVDD a_5177_1929# 0.012351f
C5927 a_995_4399# a_5667_4221# 2.51e-20
C5928 a_1037_4625# a_2815_4399# 2.24e-20
C5929 a_5943_2767# a_4544_3855# 0.044609f
C5930 a_1692_4399# a_5689_5309# 4.45e-21
C5931 a_3240_4765# a_2327_4520# 6.11e-20
C5932 a0 a_2815_4765# 8.08e-19
C5933 a_763_1256# b3 0.005905f
C5934 a_5837_1831# a_3537_1367# 7.9e-20
C5935 b2 a_553_1679# 4.18e-21
C5936 a_1697_743# a_2723_1135# 0.004593f
C5937 a_6412_4007# a_6219_5309# 6.74e-21
C5938 b3 a_2459_4765# 0.035373f
C5939 a_6296_2767# a_3891_3432# 1.19e-19
C5940 a_2325_5713# a_3537_6807# 3.68e-19
C5941 a0 a_5264_4943# 1.82e-19
C5942 a_1697_743# a_4456_1501# 0.005909f
C5943 a_4751_1831# a_5002_1501# 0.001173f
C5944 DVDD a_3847_3855# 1.34539f
C5945 a_3663_1135# a_5779_4943# 0.010633f
C5946 a_4535_854# a_2341_2455# 0.169874f
C5947 a_995_4399# a_4379_3677# 2.58e-20
C5948 a_5545_2925# a_1692_4399# 2.89e-19
C5949 a_5135_6031# a_5653_5095# 0.001153f
C5950 b2 a_317_5095# 9.09e-19
C5951 a5 a_1823_4943# 0.034697f
C5952 a_3387_6031# a_5779_4943# 1.02e-20
C5953 a_5009_6183# a_5821_5101# 0.001142f
C5954 a_1497_6189# a_2325_5713# 5.06e-19
C5955 P11 a_1775_4118# 6.75e-19
C5956 a2 a_5192_5309# 3.2e-19
C5957 a_3983_5608# a_3905_5719# 0.820137f
C5958 a_5219_6397# a_2235_5608# 7.09e-20
C5959 a_4535_854# a_2980_1135# 0.016039f
C5960 a_4533_2449# a_3164_2223# 3.91e-19
C5961 DVDD a_4732_3311# 7.2e-19
C5962 a1 a_6737_3855# 3.91e-20
C5963 DVDD a_961_1831# 1.03137f
C5964 a_2157_5719# a_2263_4221# 1.67e-21
C5965 a_2459_4399# a_2235_5608# 1.12e-19
C5966 a_317_743# a_2723_1501# 1.82e-20
C5967 b5 a_4544_3855# 0.084255f
C5968 a_3523_3030# a_4636_3311# 0.062506f
C5969 a_1421_2919# a_2459_3311# 9.64e-19
C5970 a_1697_743# a_4528_1135# 0.007691f
C5971 b5 a_3757_3855# 2.92e-20
C5972 a_4751_1831# a_5002_1174# 7.27e-19
C5973 a_4528_6575# a_627_5487# 1.9e-19
C5974 a2 a_5265_5807# 4.24e-19
C5975 a2 a_5173_3631# 3.22e-19
C5976 a_485_749# a_443_591# 0.219094f
C5977 b4 a_3537_1367# 1.04e-19
C5978 a0 a_4471_5853# 4.58e-19
C5979 a_2417_4625# a_4351_5206# 7.89e-20
C5980 a_501_5719# a_481_6281# 0.114755f
C5981 a_2815_3677# a_3240_3677# 8.12e-20
C5982 DVDD a_1880_2045# 5.37e-19
C5983 a_2467_2223# a_1775_854# 0.041371f
C5984 a_4073_4625# a_4728_4399# 0.196505f
C5985 a_4457_743# a_1823_4943# 0.040834f
C5986 a_1497_6189# a_984_6183# 0.014099f
C5987 a_995_4399# a_1775_854# 2.57e-21
C5988 a_1508_1135# a_395_854# 8.68e-20
C5989 b5 a_443_591# 5.14e-22
C5990 a_2327_3432# a_2235_1256# 3.44e-21
C5991 a_1435_4765# a_1692_4399# 0.023012f
C5992 a_4268_2767# a_4544_3855# 0.002701f
C5993 b2 a_2193_5853# 8.3e-19
C5994 b3 a_1987_3133# 9.59e-20
C5995 a0 a_1733_5309# 7.94e-20
C5996 a_2327_4520# a_2263_5309# 2.75e-20
C5997 a_4364_3133# a_3891_3432# 9.23e-20
C5998 a_5923_2223# a_5227_3855# 0.004279f
C5999 a_5188_2223# a_6412_4007# 0.022686f
C6000 a_2325_5713# a3 0.028367f
C6001 a_2467_2223# a_573_4105# 4.87e-19
C6002 a_481_6031# a1 3.48e-20
C6003 a2 a_4896_5487# 6.79e-20
C6004 a_4073_4625# a_3072_3311# 0.010899f
C6005 a_3983_4520# a_3847_3855# 1.78e-19
C6006 a_3799_4118# a_1823_3855# 2.02e-20
C6007 a_995_4399# a_573_4105# 2.48e-19
C6008 a2 a_1775_4118# 0.001503f
C6009 a_2375_4399# a_6412_4007# 5.59e-19
C6010 b4 a_1328_3677# 1.52e-19
C6011 a_2980_5487# a1 0.105213f
C6012 a_4709_1929# a_1865_4013# 0.034462f
C6013 a_2367_1501# a_2723_1501# 0.008475f
C6014 a_2493_1679# a_1823_3855# 0.001077f
C6015 a0 a_1907_3855# 5.02e-21
C6016 a_3517_4943# a_2249_4631# 8.93e-20
C6017 a0 a_5265_4719# 9.62e-20
C6018 a_5284_2589# a_4533_2449# 3.5e-19
C6019 a_2327_3432# a_3072_4399# 1.68e-20
C6020 a_2375_3311# a_1823_4943# 3.17e-19
C6021 a_3983_5608# a_4115_5487# 0.02567f
C6022 a_2045_2223# a_3164_2223# 0.090544f
C6023 DVDD a_4544_3855# 0.919768f
C6024 a_4625_749# a_2244_2767# 4.58e-20
C6025 a_395_2344# a_409_3543# 0.713798f
C6026 a_4268_2767# a_443_591# 0.001048f
C6027 a4 a_3799_4118# 1.75e-20
C6028 a_395_854# a_527_957# 0.034302f
C6029 a_317_743# a_883_957# 0.013676f
C6030 a_1823_3855# a_1865_749# 5.37e-19
C6031 a_3799_4118# a_4023_3311# 3.97e-20
C6032 a_4073_4625# a_4379_3311# 1.1e-20
C6033 b4 a_4896_4765# 3.94e-19
C6034 a_995_4399# a_1039_1942# 2.14e-21
C6035 a_2249_4631# a_849_3017# 1.29e-21
C6036 a_2375_4399# a_1421_2919# 1.71e-21
C6037 a_1865_4013# a_3072_3311# 0.134557f
C6038 a_5284_2223# a_3663_1135# 3.61e-21
C6039 a_4471_4399# a_4351_5206# 7.93e-20
C6040 a_2459_3677# a_1037_4625# 2.44e-19
C6041 a_3537_1367# a_3571_2767# 0.904863f
C6042 a1 a_6572_4943# 1.95e-19
C6043 a_995_4399# a_2283_5487# 2.94e-20
C6044 a5 a_763_1256# 0.005519f
C6045 b4 a_259_1831# 6.03e-19
C6046 a_2263_4943# a_1865_4013# 6.25e-21
C6047 a_961_1831# a_1880_1679# 5.43e-19
C6048 a_2980_5487# a_4115_4765# 5.46e-21
C6049 a_481_6281# a2 0.021521f
C6050 a_1421_2919# a_849_4105# 0.001349f
C6051 a_259_1831# a_1251_1135# 0.003858f
C6052 a_5135_6031# a_5863_4943# 1.65e-20
C6053 a_2157_5719# a_2327_4520# 2.12e-19
C6054 a_849_4105# a_443_4943# 2.18e-21
C6055 a_4379_3311# a_1865_4013# 0.005576f
C6056 a_2263_6575# b0 0.003476f
C6057 DVDD a_443_591# 0.486904f
C6058 a4 a_1823_3855# 0.053529f
C6059 a_5837_1831# a_5075_1148# 8.27e-19
C6060 a_619_3311# a_975_3311# 0.009846f
C6061 a_1784_1679# a_1952_1679# 0.008306f
C6062 a0 a_627_5487# 0.169267f
C6063 b1 a_3517_5487# 4.27e-19
C6064 b3 a_3537_6807# 2.97e-20
C6065 a_2688_591# a_317_743# 1.54e-19
C6066 a_1692_4399# a_1079_4399# 8.82e-19
C6067 b4 a_4839_5309# 4.37e-19
C6068 a_2157_5719# a_2193_5487# 5.12e-20
C6069 DVDD a_4180_1679# 7.21e-20
C6070 a_501_5719# P1 8.14e-19
C6071 b2 a_4636_3311# 0.076514f
C6072 a_1455_6031# a0 0.065686f
C6073 a_3387_6031# a_2327_4520# 2.44e-21
C6074 a_2235_5608# a_2283_5487# 0.815022f
C6075 a_2980_5487# a_2417_4625# 1.14e-20
C6076 a_1497_6189# b3 6.9e-21
C6077 a_849_3017# a_1435_4399# 1.62e-21
C6078 b4 a_1400_3311# 3.14e-20
C6079 a_4575_2589# a_1775_854# 0.066113f
C6080 a_2689_6031# a_2375_4399# 1.88e-22
C6081 a_3983_5608# a_2249_4631# 2.35e-20
C6082 a_4625_749# a_6756_1679# 9.54e-19
C6083 b1 a_3799_4118# 4.47e-19
C6084 a_6173_2223# a_5503_2767# 0.065679f
C6085 a_3799_4118# a_3931_4221# 0.025411f
C6086 a_3983_4520# a_4544_3855# 0.001446f
C6087 a_4073_4625# a_4287_4221# 0.001974f
C6088 a_2375_4399# a_4712_4221# 9.36e-21
C6089 a_4636_3311# a_4535_854# 4.77e-20
C6090 a_3573_6575# a_1775_6696# 0.006823f
C6091 DVDD a_3471_2045# 0.162119f
C6092 a_3609_4399# a_3931_3855# 2.74e-20
C6093 a_4073_4625# a_3891_3432# 6.78e-19
C6094 a_947_4520# a_1401_3855# 0.009374f
C6095 DVDD a_2616_4221# 2.76e-19
C6096 a_1775_854# a_2341_2455# 0.073704f
C6097 a_4528_6575# DVDD 6.74e-19
C6098 a_2327_3432# a_2815_4765# 3.13e-20
C6099 DVDD a_353_957# 5.88e-19
C6100 a5 a_1987_3133# 0.008111f
C6101 b1 a_1823_3855# 0.006489f
C6102 a_1823_6575# a_1508_1135# 1.46e-20
C6103 a_4483_4943# a_3523_3030# 7.96e-22
C6104 a_4839_4943# a_3813_3543# 7.97e-21
C6105 a_757_6281# a_1907_5309# 1.25e-19
C6106 a_4287_4221# a_1865_4013# 0.001053f
C6107 a_2249_3543# a_3847_3855# 0.011361f
C6108 a_553_1679# a_1775_854# 0.08153f
C6109 a_4847_1653# a_5177_1929# 2.82e-19
C6110 a_1697_743# a_4709_1929# 0.100354f
C6111 a3 a_883_4943# 1.87e-19
C6112 a0 a_1125_3017# 3.17e-20
C6113 a_1775_854# a_2980_1135# 1.09e-19
C6114 a_317_2455# a_895_1501# 8.91e-19
C6115 b4 a_1508_1135# 0.03979f
C6116 a_2907_2589# a_1125_3017# 0.052721f
C6117 a_3241_3855# a_1823_3855# 2.53e-20
C6118 a_3891_3432# a_1865_4013# 0.126526f
C6119 a5 a_1733_3855# 2.77e-19
C6120 a_763_1256# a_1676_1501# 2.57e-20
C6121 a_5264_5309# a_2283_5487# 8.71e-20
C6122 a_2249_4631# a_1329_6183# 1.84e-21
C6123 a1 P2 1.86e-19
C6124 b1 a4 0.072254f
C6125 a_1508_1135# a_1251_1135# 0.02283f
C6126 a_5837_1831# P6 1.67e-19
C6127 a2 P1 1.34e-21
C6128 DVDD P0 0.218726f
C6129 a3 b3 0.468591f
C6130 a0 b5 0.088767f
C6131 a5 a_6020_3855# 1.34e-20
C6132 a_3983_5608# a_4180_6031# 2.61e-20
C6133 a_469_1929# a_317_743# 8.42e-21
C6134 a2 a_3523_3030# 8.8e-20
C6135 a_4751_1831# a_5227_3855# 1.21e-19
C6136 a_553_1679# a_573_4105# 3.82e-19
C6137 a_4847_1653# a_3847_3855# 0.004018f
C6138 b1 a_5219_6031# 0.001101f
C6139 a_481_6281# a_2263_6941# 6.11e-20
C6140 a_4728_4399# a_5821_5101# 0.051703f
C6141 a_4667_591# a_5023_591# 0.008475f
C6142 a_6047_2045# a_1823_4943# 0.089209f
C6143 a_961_1831# a_2249_3543# 1.25e-19
C6144 a_1039_1942# a_2341_2455# 1.16e-19
C6145 a_297_3017# a_961_1831# 0.075203f
C6146 a_395_2344# a_975_3677# 0.036223f
C6147 a3 a_3076_5487# 1.49e-19
C6148 a_4103_6575# a_3517_5487# 2.92e-19
C6149 a3 a_1328_3311# 1.44e-19
C6150 a_1865_4013# a_4860_1367# 0.081591f
C6151 a1 a_619_3311# 8.98e-21
C6152 a_2341_2455# a_2283_5487# 4.95e-22
C6153 a_4943_1653# a_2244_2767# 6.69e-20
C6154 a_1860_4399# a_1435_4399# 1.31e-19
C6155 DVDD a_4471_4765# 8.24e-19
C6156 a_627_5487# a_1067_5487# 0.003858f
C6157 P9 a_2520_3855# 4.44e-21
C6158 a_2235_1256# a_1421_2919# 4.72e-20
C6159 a_553_1679# a_1039_1942# 0.299653f
C6160 DVDD a_6005_2223# 0.005678f
C6161 a_5227_3855# a_4399_4943# 6.17e-20
C6162 a_573_4105# a_317_5095# 8.13e-19
C6163 a_3571_2767# a_5075_1148# 9.13e-20
C6164 a_995_4399# a_1435_4765# 0.03106f
C6165 a_627_5487# a_1067_5853# 0.031956f
C6166 a_6412_4007# a_6403_2045# 0.040225f
C6167 a_1037_4625# a_2249_4631# 1.4e-19
C6168 a_685_1367# a_395_854# 0.005733f
C6169 a_501_5719# b2 0.085473f
C6170 a_3164_2223# a_1775_4118# 3.5e-21
C6171 b0 a_5928_6397# 8.59e-20
C6172 a_1895_6397# a_501_5719# 0.02283f
C6173 a4 a_5779_4943# 0.311334f
C6174 a_1497_6189# a_1420_5853# 1.5e-20
C6175 a_2327_3432# a_2244_2767# 0.011825f
C6176 a_2459_3677# a_1775_4118# 4.25e-19
C6177 a_1697_743# a_1784_1679# 0.050994f
C6178 a_4575_2589# a_4931_2589# 0.008475f
C6179 a_1497_6189# a5 1.59e-19
C6180 a_4528_1501# a_3663_1135# 1.39e-19
C6181 a_1329_6183# a_1435_4399# 2.57e-21
C6182 a_4805_2767# b5 4.73e-20
C6183 b1 a_1539_6031# 0.005512f
C6184 a_3387_6031# a_5135_6031# 0.173564f
C6185 DVDD a0 1.39694f
C6186 b0 a_5837_1831# 1.45e-20
C6187 DVDD a_4309_5309# 4.94e-19
C6188 a_573_4105# a_573_3855# 0.009527f
C6189 a_4625_749# a_4268_2767# 1.64e-19
C6190 DVDD a_2907_2589# 8.18e-19
C6191 a_2493_1929# a_1823_3855# 0.067551f
C6192 b1 a_3931_4221# 4.59e-19
C6193 a_1823_3855# a_2263_4221# 0.003858f
C6194 a_1865_4013# a_2520_3855# 0.097599f
C6195 a1 a_4073_4625# 0.089081f
C6196 a_4931_2589# a_2341_2455# 0.006132f
C6197 DVDD a_2723_5487# 0.153641f
C6198 a_3757_3855# a_2249_3543# 6.94e-20
C6199 a_4103_1501# a_4528_1501# 8.12e-20
C6200 a_353_591# a_443_591# 0.006958f
C6201 b2 a_1860_4765# 1.91e-19
C6202 DVDD a_4625_749# 1.38155f
C6203 a_3813_3543# a_4804_3677# 9.21e-20
C6204 a_6173_1455# a_3663_1135# 0.001924f
C6205 a_4456_6575# P3 0.004869f
C6206 a_2616_957# a_317_743# 1.11e-19
C6207 a_4805_2767# a_4268_2767# 1.41e-19
C6208 a_3523_3030# a_4732_3677# 3.73e-20
C6209 a_2263_957# a_395_854# 0.036631f
C6210 a_1907_957# a_485_749# 0.030587f
C6211 a_4636_3311# a_4379_3677# 0.024952f
C6212 a_2341_2455# a_5545_2925# 0.0096f
C6213 b0 a_2520_6575# 0.157214f
C6214 a_4847_1653# a_4544_3855# 1.8e-19
C6215 a1 a_1865_4013# 6.56e-19
C6216 a_2375_4399# a_4896_4765# 7.6e-20
C6217 a_995_4399# a_1079_4399# 0.030161f
C6218 a_3799_4118# a_3941_4765# 0.006958f
C6219 a_3609_4399# a_4824_4765# 2.54e-19
C6220 a_3983_4520# a_4471_4765# 0.044976f
C6221 a_1733_6575# a2 7.36e-20
C6222 a_1037_4625# a_1435_4399# 0.084843f
C6223 a_4073_4625# a_4115_4765# 0.033252f
C6224 a_6173_2223# a_5923_2223# 0.025037f
C6225 a_1697_743# a_3891_3432# 3.54e-21
C6226 b0 a_1823_6575# 0.068893f
C6227 a_4493_591# a_4457_743# 6.46e-20
C6228 a1 a_1733_4943# 1.81e-19
C6229 a5 a_5503_2767# 8.33e-19
C6230 a_2193_5853# a_2283_5487# 0.006958f
C6231 a_2367_5853# a_2235_5608# 0.017809f
C6232 b1 a_5779_4943# 1.26e-20
C6233 b0 b4 0.003829f
C6234 a2 b2 0.734629f
C6235 a3 a5 0.271939f
C6236 a_1895_6397# a2 1.23e-19
C6237 P4 a_5821_5101# 4.05e-19
C6238 P6 a_4031_5487# 2.63e-19
C6239 a_1692_4399# a_2285_4765# 7.56e-20
C6240 DVDD a_4824_4399# 4.94e-19
C6241 a_4544_3855# a_5653_5095# 0.002607f
C6242 a_763_1256# a_297_4105# 2.23e-19
C6243 a_4533_2449# a_1823_4943# 2.47e-21
C6244 b4 a_3813_3543# 0.340518f
C6245 a_1784_1679# a_1907_591# 1.8e-19
C6246 a_3891_3432# a_5821_5101# 8.47e-20
C6247 a_4847_1653# a_443_591# 1.06e-19
C6248 a_1697_743# a_4860_1367# 0.006181f
C6249 a_4575_2223# a_3847_3855# 0.033026f
C6250 a_3471_6031# a_2283_5487# 0.002061f
C6251 a_2285_3311# a_1775_4118# 6.71e-20
C6252 DVDD a_883_2589# 8.27e-19
C6253 a_2980_1135# a_5923_1135# 0.070958f
C6254 a0 a_3983_4520# 0.0057f
C6255 a_3609_4399# a_4483_5309# 2.73e-20
C6256 a_4073_4625# a_2417_4625# 0.002515f
C6257 a_3799_4118# a_2327_4520# 4.98e-20
C6258 b3 a_3609_4399# 0.184342f
C6259 a_763_1256# a_849_3017# 8.52e-19
C6260 a_219_1929# a_1039_1942# 2.74e-19
C6261 a5 a_997_2045# 1.91e-20
C6262 a2 a_4535_854# 0.155732f
C6263 a_1236_591# a_395_854# 7.33e-20
C6264 a_1308_591# a_317_743# 0.001063f
C6265 a_883_591# a_485_749# 0.045338f
C6266 a_1697_743# a_3827_1679# 0.003709f
C6267 a_2157_5719# a_1775_6696# 0.028559f
C6268 a_4751_1831# a_4252_1679# 1.64e-19
C6269 P10 a_1697_743# 7.4e-19
C6270 b3 a_1527_1679# 5.31e-20
C6271 a_4457_743# a_5503_2767# 0.324068f
C6272 a_5284_2223# a4 6.9e-20
C6273 a_3164_2223# a_317_743# 9.87e-21
C6274 b1 a_2263_4221# 0.004957f
C6275 a_1329_6183# a_1823_4943# 4.97e-20
C6276 a_4943_1653# b5 4.82e-19
C6277 a_2551_2589# a_1865_4013# 1.35e-20
C6278 a_2377_2589# a_1823_3855# 2.08e-19
C6279 a_1823_3855# a_2327_4520# 9.87e-20
C6280 a_1865_4013# a_2417_4625# 6.3e-19
C6281 DVDD a_1067_5487# 0.155996f
C6282 a_2688_3855# a_2520_3855# 0.008308f
C6283 a_3471_6397# a_3537_6807# 1.68e-19
C6284 a0 a_1308_4943# 6.96e-19
C6285 a_2243_1929# a_2045_2223# 0.005131f
C6286 a_1907_4943# a_2327_4520# 1.98e-20
C6287 DVDD a_1067_5853# 8.26e-19
C6288 a_3387_6031# a_1775_6696# 3.96e-20
C6289 a_3537_1367# a_3573_1501# 4.78e-19
C6290 a_5188_2223# a_5075_1148# 3.69e-20
C6291 a3 a_1236_2223# 4.54e-20
C6292 DVDD a_1907_957# 0.149938f
C6293 a_1400_3311# a_849_4105# 1.8e-21
C6294 a_2235_1256# a_3537_1367# 0.047479f
C6295 a_5227_3855# a_4351_5206# 7.62e-21
C6296 a_1697_743# a_3297_2045# 1.7e-20
C6297 a_3523_3030# a_3164_2223# 0.787776f
C6298 a_1697_743# a_2520_3855# 0.092469f
C6299 a_2327_3432# a_1125_3017# 0.069257f
C6300 b2 a_2815_4399# 7.43e-21
C6301 b0 a_4031_5487# 0.59585f
C6302 a_3813_3543# a_3571_2767# 9.65e-19
C6303 DVDD a_3573_1135# 4.94e-19
C6304 a_757_6281# P2 0.03574f
C6305 b4 a_685_1367# 1.03e-19
C6306 a_4636_3311# a_2283_5487# 4.63e-21
C6307 a3 a_2375_3311# 0.010247f
C6308 a_5095_1929# a_1865_4013# 3.98e-19
C6309 a_2327_3432# b5 4.63e-19
C6310 a_395_2344# a4 0.033382f
C6311 a_2045_2223# a_1823_4943# 2.62e-21
C6312 a_4943_1653# a_4268_2767# 0.020228f
C6313 a_2249_4631# a_1775_4118# 0.004744f
C6314 a_3799_4118# a_4115_4399# 0.040159f
C6315 a_3983_4520# a_4824_4399# 3.03e-19
C6316 a_4073_4625# a_4471_4399# 0.10898f
C6317 a_3609_4399# a_4896_4399# 3.39e-20
C6318 a_2375_4399# a_1508_1135# 8.47e-19
C6319 a_1037_4625# a_1823_4943# 0.001309f
C6320 a_2616_6575# a_1329_6183# 1.43e-20
C6321 a_6173_2543# a_4943_1653# 0.002065f
C6322 a_685_1367# a_1251_1135# 0.012599f
C6323 a_1171_1679# a_1508_1135# 9.66e-19
C6324 a_4103_6941# a_627_5487# 0.005557f
C6325 a_1079_4765# a_1435_4765# 0.008475f
C6326 a_4456_6941# a_3537_6807# 2.54e-19
C6327 a_5943_3133# a_4535_854# 0.036126f
C6328 a_1865_4013# a_4667_957# 3.84e-19
C6329 a_2325_5713# a_3261_6183# 5.89e-19
C6330 a_849_4105# a_1508_1135# 0.101896f
C6331 a_2520_3855# a_3297_1679# 1.24e-19
C6332 b2 a_2263_6941# 1.1e-19
C6333 a_6092_4221# a_1692_4399# 6.85e-21
C6334 a_3168_4399# a_1692_4399# 8.28e-20
C6335 a_4528_6941# b4 3.95e-20
C6336 a_1865_4013# a_4471_4399# 3.38e-19
C6337 a_849_3017# a_1987_3133# 0.005326f
C6338 a_1421_2919# a_2244_2767# 0.150473f
C6339 a_6368_3133# a_6412_4007# 1.46e-21
C6340 a_4436_2767# a_1865_4013# 1.63e-19
C6341 a_4011_2767# a_3072_3311# 9.42e-20
C6342 a_5667_3855# a_1692_4399# 0.046785f
C6343 DVDD a_4943_1653# 1.24044f
C6344 a_6737_3855# a_5227_3855# 4.86e-21
C6345 a_2327_3432# a_4268_2767# 2.97e-20
C6346 DVDD a_5319_1174# 4.86e-20
C6347 a_2980_5487# a_3747_6941# 9.35e-20
C6348 a_2375_3311# a_4011_3133# 0.110618f
C6349 a_3813_3543# a_3655_3133# 9.09e-19
C6350 a_1455_6031# a_4103_6941# 4.42e-20
C6351 DVDD a_883_591# 0.002468f
C6352 a1 a_5821_5101# 0.014508f
C6353 a_1775_854# a_883_957# 3.35e-19
C6354 a_527_2223# a_883_2223# 0.009846f
C6355 a_481_6281# a_2249_4631# 1.6e-19
C6356 a2 a_5219_6397# 7.45e-19
C6357 b0 a_6219_5309# 9.59e-20
C6358 a_1421_2919# a_1907_3855# 4.47e-21
C6359 a_4364_2767# a4 2.62e-19
C6360 a_259_1831# a_2235_1256# 6.04e-20
C6361 b1 a_2327_4520# 0.283308f
C6362 a2 a_5137_3855# 3.36e-19
C6363 a_961_1831# a_409_3543# 0.114442f
C6364 a0 a_297_3017# 1.12e-19
C6365 DVDD a_2327_3432# 1.26167f
C6366 b1 a_395_2344# 2.76e-19
C6367 a_2907_2589# a_2249_3543# 1.54e-20
C6368 a5 a_3609_4399# 5.9e-20
C6369 P11 a_1775_854# 0.031557f
C6370 a_5009_6183# a_4728_4399# 3.97e-20
C6371 a_1823_6575# a_1692_4399# 0.002302f
C6372 a_3983_5608# a_4115_5853# 0.022639f
C6373 P6 a_2375_4399# 8.05e-19
C6374 a_2688_591# a_1775_854# 2.57e-20
C6375 a_3847_3855# a_3663_1135# 9.5e-19
C6376 a_4636_3311# a_5545_2925# 0.06079f
C6377 a_6412_4007# a_6756_1679# 0.005587f
C6378 b4 a_1692_4399# 0.039724f
C6379 a_2551_2589# a_1697_743# 4.22e-19
C6380 a_757_6281# a_1865_4013# 9.16e-19
C6381 a_2263_6575# a_2235_5608# 2.56e-20
C6382 a_4456_6941# a3 3.93e-21
C6383 a_2341_2455# a_3076_1501# 6.2e-20
C6384 a_627_5487# a_443_4943# 0.130326f
C6385 a_5219_6397# a_5575_6397# 0.009846f
C6386 a_1865_4013# a_5002_1501# 0.00124f
C6387 a_2781_2767# a_2244_2767# 1.41e-19
C6388 a_3847_3855# a_4103_1501# 1.8e-20
C6389 a_481_6281# a_1435_4399# 3.68e-21
C6390 b2 a_3164_2223# 0.003463f
C6391 a_2907_2223# a_2467_2223# 0.009397f
C6392 a_3260_2223# a_2045_2223# 3.35e-19
C6393 a_4457_743# a_5923_2223# 0.030232f
C6394 a0 a_5653_5095# 0.059108f
C6395 a_4839_5309# a_3072_4399# 0.011819f
C6396 a_4483_5309# a_4399_4943# 0.030161f
C6397 b2 a_2459_3677# 0.00278f
C6398 a_2467_2223# a_395_854# 5.01e-20
C6399 b2 a_3905_5719# 2.15e-20
C6400 a_501_5719# a_2283_5487# 3.95e-19
C6401 b3 a_4399_4943# 5.54e-19
C6402 a_6296_2767# a_5227_3855# 7.33e-20
C6403 a5 a_3168_3311# 6.77e-20
C6404 a_1697_743# a_5095_1929# 0.075916f
C6405 a_4847_1653# a_4625_749# 0.220477f
C6406 a_5135_6031# a4 2.49e-20
C6407 a_5009_6183# a_5575_6031# 0.051608f
C6408 a_1455_6031# a_443_4943# 0.001388f
C6409 a_3387_6031# a_5928_6031# 7.33e-20
C6410 a_5667_4221# a_6020_4221# 2.18e-19
C6411 a_5135_6031# a_5219_6031# 0.059385f
C6412 a_2980_1135# a_3076_1501# 0.005587f
C6413 a_6047_2045# a_5503_2767# 0.001786f
C6414 a_5587_3133# a_5943_3133# 0.009846f
C6415 a_2459_4399# a_2815_4399# 0.009846f
C6416 a_4011_2767# a_3891_3432# 7.93e-20
C6417 a2 a_1775_854# 0.006116f
C6418 b0 a_2375_4399# 0.079072f
C6419 a_395_2344# a_527_2589# 0.024438f
C6420 a_297_3017# a_883_2589# 1.41e-20
C6421 a_3471_6031# a_3827_6031# 0.008475f
C6422 a_3571_2767# a_1692_4399# 2.27e-20
C6423 a_2375_3311# a_3609_4399# 7.39e-20
C6424 a_3813_3543# a_2375_4399# 1.25e-20
C6425 a_3523_3030# a_2249_4631# 2.68e-20
C6426 a_1784_1679# a_2723_1135# 0.011819f
C6427 a_2243_1929# a_1775_4118# 0.021085f
C6428 a_2235_1256# a_1508_1135# 2.74e-19
C6429 a_1692_4399# a_4031_5487# 0.929403f
C6430 a1 a_6219_4943# 0.001353f
C6431 b2 a_3481_3133# 2.65e-20
C6432 a3 a_297_4105# 7.59e-20
C6433 b0 a_849_4105# 0.030109f
C6434 a_2263_4221# a_2327_4520# 2.35e-19
C6435 a_3517_5487# a_1775_6696# 0.556917f
C6436 b5 a_6412_4007# 0.070035f
C6437 a_3983_5608# a_3537_6807# 0.046333f
C6438 a3 a_3517_4943# 5.22e-20
C6439 a_4483_4943# a_2283_5487# 0.033252f
C6440 a_1784_1679# a_317_2455# 9.15e-21
C6441 a_3813_3543# a_849_4105# 9.69e-20
C6442 a_4309_4943# a_3905_5719# 1.73e-19
C6443 a_3261_6183# b3 0.00116f
C6444 a_4103_6941# DVDD 0.046162f
C6445 a_1421_2919# a_1125_3017# 0.050744f
C6446 a_4379_3677# a_4732_3677# 2.18e-19
C6447 a_1775_4118# a_1823_4943# 0.039975f
C6448 a_4544_3855# a_3663_1135# 7.58e-19
C6449 a_961_1831# a_1631_3133# 0.001015f
C6450 a3 a_849_3017# 0.076032f
C6451 a_1455_6031# a_2689_6031# 1.15e-19
C6452 b5 a_1421_2919# 8.3e-20
C6453 a_3387_6031# a_2248_6031# 3.83e-21
C6454 a2 a_2283_5487# 0.083153f
C6455 a_5135_6031# b1 0.005674f
C6456 a_4931_2223# a_5356_2223# 1.31e-19
C6457 a_5009_6183# P4 4.68e-19
C6458 P5 a_2235_5608# 0.002579f
C6459 b5 a_443_4943# 4.89e-19
C6460 b4 a_4712_3855# 7.98e-20
C6461 a_975_3677# a_961_1831# 0.023014f
C6462 a5 a_1401_3855# 1.49e-19
C6463 a_3537_1367# a_2244_2767# 0.162415f
C6464 a_1697_743# a_2263_591# 0.046858f
C6465 a_2375_3311# a_3168_3311# 1.63e-19
C6466 a_2327_3432# a_3240_3311# 3.18e-19
C6467 b2 a_2285_3311# 5.01e-20
C6468 a_4268_2767# a_6412_4007# 2.44e-20
C6469 a_4436_3133# a_3847_3855# 4.29e-20
C6470 a5 a_2263_3855# 0.00381f
C6471 a_1907_6941# a_2263_6941# 0.008475f
C6472 DVDD a_5873_2045# 4.94e-19
C6473 a_469_1929# a_1039_1942# 5.1e-19
C6474 a_1037_4625# a_1733_3855# 2.22e-19
C6475 a_627_5487# a_1401_6895# 6.27e-19
C6476 a_6368_2767# a_4544_3855# 1.46e-19
C6477 a_1823_6575# a_1733_6941# 0.006958f
C6478 a_443_591# a_3663_1135# 0.022421f
C6479 a_4533_2449# a_5587_2767# 0.00117f
C6480 a_481_6281# a_1823_4943# 1.13e-19
C6481 a_3609_4719# a_2417_4625# 1.98e-19
C6482 b3 a_3168_4765# 0.001152f
C6483 a_1697_743# a_3148_1135# 5.4e-20
C6484 a5 a_721_1501# 6.02e-20
C6485 a_1171_1679# a_685_1367# 0.009323f
C6486 a4 a_1631_2767# 0.002794f
C6487 a0 a_5863_4943# 0.00244f
C6488 DVDD a_6412_4007# 1.01325f
C6489 a_1697_743# a_5002_1501# 5.69e-19
C6490 a_317_2455# a_975_3311# 1.71e-20
C6491 a_1497_6189# a_1329_6183# 0.491789f
C6492 a_685_1367# a_849_4105# 4.56e-21
C6493 a5 a_4399_4943# 3.9e-21
C6494 a_5135_6031# a_5779_4943# 0.001036f
C6495 a_2907_2223# a_2341_2455# 0.015103f
C6496 a_2980_5487# a_2325_5713# 0.081378f
C6497 a_2341_2455# a_395_854# 4.06e-21
C6498 DVDD a_1421_2919# 0.773154f
C6499 a_2781_2767# a_1125_3017# 7.29e-19
C6500 a_4533_2449# a_5503_2767# 0.028045f
C6501 a2 a_4931_2589# 3.33e-19
C6502 a_5311_4221# a_4031_5487# 0.038918f
C6503 DVDD a_443_4943# 1.15023f
C6504 a3 a_1860_4399# 9.35e-21
C6505 a_995_4399# a_1823_6575# 2.43e-20
C6506 a_2815_4399# a_2283_5487# 8.7e-21
C6507 a_1775_854# a_2616_957# 4.95e-20
C6508 a_4457_743# a_4751_1831# 0.024874f
C6509 a_4943_1653# a_4847_1653# 0.05893f
C6510 a_501_5719# a_1435_4765# 1.58e-20
C6511 a_1308_2589# b3 0.00123f
C6512 b4 a_2467_2223# 3.11e-19
C6513 a_553_1679# a_395_854# 7.88e-20
C6514 a_2243_1929# a_317_743# 0.001186f
C6515 a_4751_1831# a_6005_1135# 0.004322f
C6516 a2 a_3941_5487# 6.39e-20
C6517 b5 a_4287_3855# 0.002437f
C6518 b4 a_995_4399# 0.020452f
C6519 b2 a_2249_4631# 0.001745f
C6520 a2 a_5545_2925# 8.48e-20
C6521 a_395_854# a_2980_1135# 0.043268f
C6522 a_3571_2767# a_4023_3677# 1.9e-20
C6523 a_3164_2223# a_4379_3677# 2.02e-20
C6524 a_297_3017# a_2327_3432# 0.002086f
C6525 a_2327_3432# a_2249_3543# 0.78551f
C6526 a0 a_4824_5853# 6.42e-19
C6527 a_763_1256# a_1775_4118# 3.76e-19
C6528 a_1907_591# a_2263_591# 0.008475f
C6529 a_4483_5309# a_4351_5206# 0.022524f
C6530 DVDD a_469_1679# 0.001152f
C6531 b3 a_4351_5206# 0.001385f
C6532 a_1497_6189# a_1037_4625# 1.82e-19
C6533 a_4943_1653# a_5653_5095# 4.56e-21
C6534 a_757_6281# a_1907_4221# 9.64e-19
C6535 a_2520_3855# a_2723_1135# 0.00934f
C6536 a3 a_1329_6183# 2.58e-20
C6537 b2 a_2723_5853# 0.001154f
C6538 a_2520_6575# a_2235_5608# 1.39e-19
C6539 a_1435_4765# a_1860_4765# 8.12e-20
C6540 a_5188_2223# a_1692_4399# 4.74e-19
C6541 a_4268_2767# a_4287_3855# 4.75e-21
C6542 a0 a_2263_5309# 0.001467f
C6543 a_1823_6575# a_2235_5608# 0.013309f
C6544 a_2375_4399# a_1692_4399# 0.535725f
C6545 a_2249_4631# a_1788_4765# 7.41e-21
C6546 b1 a_1775_6696# 0.003277f
C6547 b0 a_3072_4399# 0.007052f
C6548 a_3799_4118# a_3847_3855# 0.147774f
C6549 a_4073_4625# a_5227_3855# 0.007f
C6550 a_4728_4399# a_3072_3311# 5.27e-19
C6551 a_5009_6183# a1 0.001907f
C6552 b4 a_2235_5608# 0.034938f
C6553 a_2723_1501# a_3076_1501# 2.18e-19
C6554 P1 a_1823_4943# 0.043787f
C6555 a_4309_4943# a_2249_4631# 2.3e-19
C6556 a_3813_3543# a_3072_4399# 4.99e-20
C6557 a_947_4520# a_1865_4013# 0.00127f
C6558 a_3523_3030# a_1823_4943# 1.37e-19
C6559 a0 a_409_3543# 1.96e-19
C6560 a_849_4105# a_1692_4399# 3.4e-19
C6561 DVDD a_4712_4221# 6.64e-19
C6562 a_3983_5608# a_4824_5487# 1.84e-19
C6563 DVDD a_1788_4399# 4.94e-19
C6564 a_2467_2223# a_3571_2767# 0.03062f
C6565 a_1775_854# a_3164_2223# 0.039695f
C6566 DVDD a_4287_3855# 9.45e-19
C6567 a_995_4399# a_3571_2767# 5.76e-20
C6568 b2 a_1435_4399# 0.006294f
C6569 a_3847_3855# a_1865_749# 6.35e-21
C6570 a_6005_2223# a_3663_1135# 4.92e-19
C6571 a_1527_1679# a_849_3017# 1.21e-20
C6572 a_1823_3855# a_3847_3855# 0.001647f
C6573 a4 a_5177_1929# 5.1e-19
C6574 a3 a_1037_4625# 0.199406f
C6575 a1 a_248_4631# 0.007584f
C6576 a_5943_3133# a_5545_2925# 0.084326f
C6577 a_995_4399# a_4031_5487# 4.28e-19
C6578 a_5837_1831# a_2341_2455# 2.02e-20
C6579 b5 a_297_3855# 2.72e-19
C6580 a0 a_2157_5719# 0.025895f
C6581 a_4023_3311# a_3847_3855# 0.003898f
C6582 a_4379_3311# a_3072_3311# 1.63e-20
C6583 a_4804_3311# a_1865_4013# 5.8e-20
C6584 a4 a_3847_3855# 0.034801f
C6585 a_2688_6575# b0 4.22e-20
C6586 a_961_1831# a_1865_749# 3.68e-20
C6587 a_5837_1831# a_2980_1135# 0.004502f
C6588 a_2244_2767# a_1508_1135# 5.58e-20
C6589 a_1987_3133# a_1775_4118# 0.00124f
C6590 a_2235_1256# a_685_1367# 1.52e-19
C6591 a_961_1831# a_1823_3855# 0.012099f
C6592 DVDD a_1401_6895# 1.49e-20
C6593 a2 a_2367_5853# 0.004566f
C6594 a_3297_6397# DVDD 4.94e-19
C6595 a_2157_5719# a_2723_5487# 0.011819f
C6596 a_2467_2223# a_3655_3133# 3.2e-20
C6597 b4 a_4575_2589# 5.9e-19
C6598 a_1907_3855# a_1508_1135# 0.04028f
C6599 a_4011_2767# a_4436_2767# 8.12e-20
C6600 a3 a_1400_3677# 8.27e-20
C6601 a_5009_6183# a_2417_4625# 8.92e-21
C6602 a_3387_6031# a0 0.096184f
C6603 a_3537_1367# a_4268_2767# 0.002543f
C6604 a_961_1831# a4 0.280915f
C6605 a_2283_5487# a_3905_5719# 0.285441f
C6606 a_2235_5608# a_4031_5487# 0.024359f
C6607 a5 a_1308_2589# 1.79e-19
C6608 a4 a_5928_6031# 1.07e-20
C6609 a_2980_5487# b3 0.179874f
C6610 a_763_1256# a_317_743# 0.020205f
C6611 a_259_1831# a_485_749# 9.49e-19
C6612 a_219_1929# a_395_854# 4.78e-19
C6613 a_4535_854# a_4103_1135# 6.15e-19
C6614 a_4943_1653# a_4575_2223# 0.001442f
C6615 a_5284_2589# a_1775_854# 3.73e-20
C6616 a_883_2223# a_317_2455# 0.014628f
C6617 b4 a_2341_2455# 0.013477f
C6618 a_527_2223# a_355_1653# 0.03883f
C6619 a_3983_5608# a_3609_4399# 2.1e-20
C6620 a_4625_749# a_3663_1135# 0.057439f
C6621 a5 a_4351_5206# 4.14e-20
C6622 a_4533_2449# a_5923_2223# 0.001039f
C6623 a_2980_5487# a_3076_5487# 0.005093f
C6624 a_1365_6031# a_947_4520# 2.04e-21
C6625 a_3799_4118# a_4544_3855# 0.080664f
C6626 a_2235_1256# a_2263_957# 4.15e-19
C6627 a_2375_4399# a_5311_4221# 0.089647f
C6628 a_4073_4625# a_4640_4221# 7.38e-20
C6629 a_2249_4631# a_2459_4399# 0.011205f
C6630 a_4103_6575# a_1775_6696# 0.003858f
C6631 a_2375_4399# a_2285_4399# 0.006823f
C6632 a_2980_1135# a_6047_1679# 0.001788f
C6633 b4 a_553_1679# 3.59e-20
C6634 b2 a_2243_1929# 3.79e-21
C6635 a_961_1831# a_1527_2045# 0.015583f
C6636 DVDD a_3537_1367# 1.23102f
C6637 a_4728_4399# a_3891_3432# 3.43e-20
C6638 a_3983_4520# a_4287_3855# 2.25e-19
C6639 DVDD a_297_3855# 1.61e-19
C6640 a_259_1831# b5 9.12e-19
C6641 a_995_4399# a_4471_5487# 1.02e-21
C6642 b0 a_5264_4943# 2.28e-19
C6643 a_984_6183# P2 0.065115f
C6644 b1 a_3847_3855# 0.001139f
C6645 a_3261_6183# a_3471_6397# 0.012695f
C6646 a_1823_6575# a_317_5095# 1.79e-19
C6647 a_2340_2767# a_1823_3855# 1.74e-19
C6648 a_4287_4221# a_3072_3311# 0.011819f
C6649 a_3931_4221# a_3847_3855# 0.030161f
C6650 a_4640_4221# a_1865_4013# 3.94e-21
C6651 a_1697_743# a_5345_1929# 0.007489f
C6652 a_1527_2045# a_1880_2045# 2.18e-19
C6653 a_4751_1831# a_6047_2045# 2.9e-20
C6654 b2 a_1823_4943# 0.035465f
C6655 a_3241_3855# a_3847_3855# 2e-20
C6656 a_3931_3855# a_1865_4013# 0.036477f
C6657 a_3891_3432# a_3072_3311# 0.014045f
C6658 a_3332_2589# a_1125_3017# 2.35e-20
C6659 a5 a_3481_2767# 3.32e-20
C6660 a_5863_5309# a_2283_5487# 1.58e-19
C6661 a_4709_1929# a_4860_1367# 0.318315f
C6662 a5 a_6737_3855# 8.77e-21
C6663 a_1508_1135# a_1676_1135# 0.00769f
C6664 b1 a_961_1831# 0.001278f
C6665 a0 a_975_3677# 2.8e-19
C6666 a_3983_5608# a_4621_6031# 0.009991f
C6667 a_1421_2919# a_2249_3543# 1.4e-19
C6668 a_297_3017# a_1421_2919# 4.16e-19
C6669 a_4847_1653# a_6412_4007# 9.49e-20
C6670 a_3168_3677# a_1865_4013# 6.75e-20
C6671 a4 a_4544_3855# 0.074098f
C6672 a_395_854# a_2723_1501# 2.27e-19
C6673 a_5177_1929# a_5779_4943# 4.67e-20
C6674 a_2340_2767# a4 1.61e-19
C6675 a_3571_2767# a_2341_2455# 0.040958f
C6676 a_849_3017# a_2263_3855# 1.08e-20
C6677 a_4379_3311# a_3891_3432# 0.015588f
C6678 a_4115_5487# a_2283_5487# 0.005962f
C6679 a_4471_5487# a_2235_5608# 0.002316f
C6680 a_1865_749# a_443_591# 0.037189f
C6681 a_2341_2455# a_4031_5487# 0.001888f
C6682 a_1907_6575# a_2263_6575# 0.009846f
C6683 a_4535_854# a_1823_4943# 0.028448f
C6684 a_1823_3855# a_443_591# 1.4e-20
C6685 a_1692_4399# a_3072_4399# 0.052416f
C6686 a_2248_6397# a_481_6281# 2.59e-19
C6687 a_3571_2767# a_2980_1135# 7.09e-19
C6688 a_3847_3855# a_5779_4943# 6.42e-19
C6689 a_5503_2767# a_5289_1433# 4.39e-22
C6690 a_5227_3855# a_5821_5101# 1.62e-20
C6691 DVDD a_259_1831# 0.731472f
C6692 a_6412_4007# a_5653_5095# 0.009648f
C6693 a_2325_5713# a_1865_4013# 2.9e-20
C6694 a_1823_6575# a_2193_5853# 1.82e-19
C6695 a_627_5487# a_1492_5853# 2.58e-20
C6696 a_6412_4007# a_6828_2045# 0.007712f
C6697 a_3517_4943# a_4399_4943# 1.62e-20
C6698 a_1508_1135# a_485_749# 4.56e-19
C6699 a_1497_6189# a_481_6281# 0.779041f
C6700 a_995_4399# a_2375_4399# 0.006217f
C6701 a4 a_443_591# 4.7e-21
C6702 b5 a_5075_1148# 1.17e-21
C6703 a_1125_3017# a_1508_1135# 0.026493f
C6704 a_2467_2223# a_849_4105# 0.00147f
C6705 a_757_6031# a1 1.31e-19
C6706 a_481_6031# a5 5.34e-19
C6707 a_3573_1135# a_3663_1135# 0.006823f
C6708 P1 a_1308_5309# 0.007578f
C6709 a_1497_6189# a_1861_5807# 0.009542f
C6710 a3 a_1775_4118# 0.209436f
C6711 a_2249_4631# a_573_4105# 3.85e-22
C6712 a_995_4399# a_849_4105# 6.09e-19
C6713 a_5223_1501# a_3663_1135# 3.69e-19
C6714 b5 a_1508_1135# 0.070375f
C6715 a_4931_2589# a_5284_2589# 2.18e-19
C6716 b0 a_5265_4719# 1.02e-19
C6717 DVDD a_4839_5309# 0.144605f
C6718 a_2723_1135# a_3148_1135# 1.31e-19
C6719 a_895_1501# a_1251_1501# 0.008475f
C6720 a_1865_4013# a_2688_4221# 2.02e-19
C6721 a_1823_3855# a_2616_4221# 4.35e-21
C6722 a_3072_3311# a_2520_3855# 1.33e-19
C6723 a1 a_4728_4399# 0.045308f
C6724 a_1775_6696# a_2193_5487# 2.7e-21
C6725 a_2327_3432# a_409_3543# 5.79e-20
C6726 a_395_854# a_883_957# 0.039296f
C6727 a_485_749# a_527_957# 0.089068f
C6728 a_4268_2767# a_5075_1148# 1.33e-20
C6729 a_317_743# a_1236_957# 1.11e-19
C6730 DVDD a_3148_5487# 4.72e-19
C6731 a_757_6281# a_248_4631# 0.003493f
C6732 b2 a_763_1256# 2.8e-21
C6733 b2 a_2459_4765# 5.9e-20
C6734 a_2375_4399# a_2235_5608# 2e-19
C6735 a_2249_4631# a_2283_5487# 0.00304f
C6736 b4 a_219_1929# 3.99e-21
C6737 DVDD a_1400_3311# 5.73e-19
C6738 a_3891_3432# a_4287_4221# 2.64e-19
C6739 a_4943_1653# a_3663_1135# 0.001984f
C6740 b3 a_619_3311# 0.00349f
C6741 a_4636_3311# a_4804_3677# 0.008482f
C6742 a_481_6281# a3 1.71e-20
C6743 a_5319_1174# a_3663_1135# 2.43e-19
C6744 a_961_1831# a_2493_1929# 3.16e-19
C6745 a_763_1256# a_895_1135# 0.033084f
C6746 b0 a_2688_6941# 7.95e-20
C6747 a_2341_2455# a_2459_3311# 2.8e-20
C6748 a1 a_3072_3311# 0.005306f
C6749 a_2412_2767# a_1697_743# 1.3e-20
C6750 a_4533_2449# a_4751_1831# 2.18e-19
C6751 a_883_5309# a_1308_5309# 1.31e-19
C6752 a_3240_3677# a_2249_3543# 1.87e-19
C6753 a_2263_6575# a2 0.022131f
C6754 a_3799_4118# a_4471_4765# 0.030255f
C6755 a_3983_4520# a_4896_4765# 0.001158f
C6756 P11 a_395_854# 4.31e-19
C6757 a1 a_2263_4943# 0.002031f
C6758 DVDD a_5075_1148# 0.374381f
C6759 a0 a_3517_5487# 0.097045f
C6760 b0 a_627_5487# 0.314719f
C6761 a_317_743# a_1604_1135# 8.88e-20
C6762 a_4493_591# a_317_743# 1.33e-19
C6763 a5 a_1457_3133# 1.49e-20
C6764 a_2688_591# a_395_854# 1.88e-19
C6765 a_2723_5853# a_2283_5487# 0.038227f
C6766 a_3076_5853# a_2235_5608# 7.33e-20
C6767 a_3983_5608# a_4399_4943# 0.001707f
C6768 a_2325_5713# a_1365_6031# 1.58e-21
C6769 a_2320_6397# b0 4.31e-20
C6770 a_573_4105# a_1435_4399# 1.78e-20
C6771 a_1784_1679# a_2520_3855# 0.035617f
C6772 DVDD a_1508_1135# 1.11813f
C6773 a_4544_3855# a_5779_4943# 0.029492f
C6774 a_5667_4221# a_1823_4943# 0.003809f
C6775 b4 a_4636_3311# 0.008517f
C6776 a_1455_6031# b0 0.009832f
C6777 b5 P6 0.018367f
C6778 a_2459_4399# a_1823_4943# 0.009435f
C6779 a_5284_2223# a_3847_3855# 2.59e-19
C6780 a_2551_2223# a_2907_2223# 0.009846f
C6781 a_4180_6031# a_2283_5487# 1.3e-19
C6782 a_4252_6031# a_2235_5608# 7.62e-20
C6783 a_3827_6031# a_3905_5719# 2.73e-19
C6784 a_4575_2589# a_5188_2223# 4.3e-19
C6785 a_4073_4625# a_4483_5309# 1.03e-19
C6786 a0 a_3799_4118# 9.24e-19
C6787 a_3799_4118# a_4309_5309# 1.27e-20
C6788 a_3983_4520# a_4839_5309# 6.11e-20
C6789 a_4483_4943# a_4839_4943# 0.008475f
C6790 b3 a_4073_4625# 3.48e-19
C6791 a_4023_3677# a_3072_4399# 2.27e-19
C6792 a_4847_1653# a_4709_1679# 2.24e-19
C6793 a_1697_743# a_4252_1679# 3.49e-19
C6794 a_4751_1831# a_4793_1679# 0.001306f
C6795 a2 a_2285_4765# 7.89e-21
C6796 a_3261_6183# a_3983_5608# 0.008864f
C6797 b1 a_2616_4221# 2.01e-19
C6798 a_5188_2223# a_2341_2455# 0.001568f
C6799 a_2375_4399# a_2341_2455# 0.001354f
C6800 a2 a_4839_4943# 0.003807f
C6801 a_2249_4631# a_5545_2925# 3.61e-20
C6802 a0 a_1823_3855# 7.55e-22
C6803 a_3072_3311# a_2417_4625# 1.89e-20
C6804 b2 a_1987_3133# 0.002668f
C6805 DVDD a_527_957# 0.167524f
C6806 a_3260_2589# a_1865_4013# 2.6e-20
C6807 DVDD a_1492_5487# 6.64e-19
C6808 b3 a_1865_4013# 2.66e-19
C6809 a_501_5719# a_1236_5309# 7.68e-20
C6810 a_2263_4943# a_2417_4625# 8.11e-19
C6811 a0 a_1907_4943# 0.005325f
C6812 a_2616_4943# a_2327_4520# 4.46e-20
C6813 a_2243_1929# a_1775_854# 0.057534f
C6814 a_5095_1929# a_4709_1929# 0.065094f
C6815 a_2235_1256# a_2467_2223# 0.174567f
C6816 a1 a_527_4943# 0.007677f
C6817 a3 a_1236_4943# 8.46e-20
C6818 a_5188_2223# a_2980_1135# 0.001498f
C6819 a_317_2455# a_1251_1501# 2.79e-19
C6820 a_2341_2455# a_849_4105# 9.04e-20
C6821 a_1697_743# a_3827_2045# 0.002361f
C6822 a_4847_1653# a_3537_1367# 7.9e-19
C6823 a_317_2455# a_573_2767# 1.31e-19
C6824 a_2327_3432# a_1631_3133# 2.8e-20
C6825 a1 P4 1.73e-19
C6826 a3 P1 4e-19
C6827 DVDD P6 0.20158f
C6828 a5 P2 0.002145f
C6829 a_1769_2543# a_1421_2919# 0.009999f
C6830 b0 b5 0.082591f
C6831 b1 P0 5.17e-21
C6832 a0 a4 7.8e-19
C6833 a_2907_2589# a4 3.63e-19
C6834 a_2980_5487# a_3471_6397# 0.022349f
C6835 a_997_2045# a_317_743# 6.44e-21
C6836 a0 a_5219_6031# 0.001082f
C6837 a_4625_749# a_1865_749# 0.213321f
C6838 a_4636_3311# a_4031_5487# 0.005605f
C6839 a_2243_1929# a_573_4105# 1.36e-20
C6840 a_3813_3543# b5 0.004f
C6841 a_553_1679# a_849_4105# 4.8e-20
C6842 a1 a_3891_3432# 0.111604f
C6843 a_2244_2767# a_1692_4399# 2.08e-20
C6844 a_297_3017# a_1328_3677# 7.33e-20
C6845 a_395_2344# a_961_1831# 0.052201f
C6846 a_995_4399# a_3072_4399# 8.19e-19
C6847 a_3799_4118# a_4824_4399# 4.35e-21
C6848 a_4728_4399# a_4471_4399# 0.024051f
C6849 a_1907_6575# a_2520_6575# 2.9e-19
C6850 a_3261_6183# a_1329_6183# 0.003046f
C6851 a5 a_619_3311# 0.004328f
C6852 b2 a_445_3311# 6.89e-21
C6853 a_6296_3133# a_4535_854# 3.34e-19
C6854 a_4528_6941# a_627_5487# 6.11e-20
C6855 a_1907_6575# a_1823_6575# 0.037224f
C6856 P10 a_2520_3855# 0.051362f
C6857 a_2243_1929# a_1039_1942# 1.64e-19
C6858 a_849_4105# a_317_5095# 5.11e-21
C6859 a4 a_4625_749# 0.00337f
C6860 a_1907_3855# a_1692_4399# 4.93e-20
C6861 a_2249_4631# a_1435_4765# 1.43e-19
C6862 a_4364_2767# a_3847_3855# 3.5e-19
C6863 a_259_1831# a_297_3017# 4.46e-20
C6864 a_6092_3855# a_1692_4399# 4.08e-19
C6865 a_849_3017# a_2340_3133# 2.59e-19
C6866 a_1421_2919# a_2412_3133# 6.73e-20
C6867 a_757_6281# a_1125_6895# 5.55e-20
C6868 a_501_5719# a_1823_6575# 0.029453f
C6869 a_3523_3030# a_4011_3133# 0.009144f
C6870 a_3813_3543# a_4268_2767# 0.045001f
C6871 DVDD a_6173_1135# 0.252759f
C6872 a3 a_883_5309# 1.77e-21
C6873 a_757_6281# a_757_6031# 0.009374f
C6874 a_1895_6397# a_2248_6397# 2.18e-19
C6875 a_685_1367# a_485_749# 0.009112f
C6876 a_1823_4943# a_2283_5487# 1.2e-19
C6877 a_3072_4399# a_2235_5608# 2.58e-19
C6878 DVDD a_1308_2223# 4.72e-19
C6879 a_1497_6189# b2 0.149802f
C6880 a_1497_6189# a_1895_6397# 0.101699f
C6881 a_1455_6031# a_1539_6397# 0.071061f
C6882 a_4805_2767# a4 1.76e-19
C6883 a_1421_2919# a_409_3543# 0.001849f
C6884 a0 a_1539_6031# 0.006465f
C6885 a_2263_4221# a_2616_4221# 2.18e-19
C6886 a_685_1367# a_1125_3017# 3.17e-20
C6887 b1 a0 0.916585f
C6888 a2 a_5837_1831# 1.01e-21
C6889 DVDD b0 2.82569f
C6890 a_5873_2045# a_3663_1135# 1.81e-20
C6891 a_4103_6575# a_4528_6575# 1.31e-19
C6892 a_409_3543# a_443_4943# 1.26e-19
C6893 DVDD a_3813_3543# 1.33021f
C6894 a4 a_883_2589# 0.001568f
C6895 b3 a_3757_4221# 1.18e-20
C6896 a5 a_4073_4625# 8.64e-19
C6897 a_3983_5608# a_4351_5206# 0.177413f
C6898 a_6005_2223# a_5779_4943# 0.001616f
C6899 a_527_591# a_443_591# 0.067761f
C6900 a2 a_4804_3677# 1.77e-19
C6901 a1 a_2520_3855# 1.31e-19
C6902 a_2263_957# a_485_749# 0.00394f
C6903 a_297_3017# a_1400_3311# 1.9e-19
C6904 a_1907_957# a_1865_749# 0.089215f
C6905 a_2616_957# a_395_854# 4.71e-19
C6906 DVDD a_301_1929# 0.011812f
C6907 a_2367_5853# a_2723_5853# 0.008475f
C6908 a_1455_6031# a_1692_4399# 1.1e-21
C6909 b3 a_1697_743# 2.91e-19
C6910 b4 a_4483_4943# 0.008068f
C6911 a_317_2455# a_355_1653# 0.933609f
C6912 a5 a_1865_4013# 0.375228f
C6913 a2 a_2520_6575# 1.77e-19
C6914 a_2157_5719# a_443_4943# 8.5e-20
C6915 a_248_4631# a_355_1653# 9.2e-21
C6916 a_763_1256# a_1775_854# 0.001016f
C6917 a_4535_854# a_5587_2767# 7.98e-20
C6918 a_248_4631# a_947_4520# 0.007912f
C6919 a2 a_1823_6575# 0.395092f
C6920 a_4667_591# a_4457_743# 0.04028f
C6921 a_5575_6397# a_5928_6397# 2.18e-19
C6922 a_5943_2767# a_1692_4399# 1.36e-20
C6923 a_763_1256# a_997_1679# 0.007261f
C6924 a_2235_1256# a_2341_2455# 0.009144f
C6925 a_3332_2223# a_2467_2223# 8.63e-21
C6926 a_5192_5309# a_4399_4943# 4.35e-21
C6927 a0 a_5779_4943# 0.028647f
C6928 a_5264_5309# a_3072_4399# 3.39e-20
C6929 a4 a_1907_957# 1.76e-20
C6930 a_2325_5713# a_2688_5309# 1.38e-19
C6931 a3 b2 0.322373f
C6932 a2 b4 0.239902f
C6933 a_4575_2223# a_3537_1367# 6.36e-20
C6934 a_763_1256# a_573_4105# 2.35e-20
C6935 a_1421_2919# a_2367_1135# 1.51e-21
C6936 a_1527_1679# a_317_743# 8.06e-19
C6937 a_4709_1929# a_5002_1174# 0.006879f
C6938 a_5135_6031# a_5928_6031# 0.001198f
C6939 a_1784_1679# a_2263_591# 7.04e-20
C6940 a_5009_6183# a_6000_6031# 1.56e-19
C6941 a_553_1679# a_2235_1256# 0.001476f
C6942 a_2980_1135# a_3573_1501# 7.56e-20
C6943 a_5943_3133# a_5837_1831# 0.02283f
C6944 a_297_3017# a_1508_1135# 5.76e-19
C6945 a_2249_3543# a_1508_1135# 0.001308f
C6946 a_4751_1831# a_5289_1433# 0.06193f
C6947 a_2235_1256# a_2980_1135# 0.075227f
C6948 a_2815_4399# a_3168_4399# 2.18e-19
C6949 a_4847_1653# a_5075_1148# 9.97e-20
C6950 a_2341_2455# a_3072_4399# 2.03e-21
C6951 a_5545_2925# a_1823_4943# 0.001828f
C6952 a_2263_3855# a_1775_4118# 0.012585f
C6953 a_2616_3855# a_1508_1135# 5.43e-19
C6954 DVDD a_685_1367# 1.25618f
C6955 a_4535_854# a_5503_2767# 0.130452f
C6956 a_5311_3855# a_5667_3855# 0.008475f
C6957 a_4943_1653# a_1865_749# 2.03e-20
C6958 a_4457_743# a_1865_4013# 7.73e-20
C6959 b0 a_3983_4520# 0.020373f
C6960 a_4625_749# a_5779_4943# 0.144804f
C6961 a1 a_4115_4765# 0.003314f
C6962 a_4636_3311# a_5188_2223# 4.23e-20
C6963 a_1308_591# a_395_854# 6.11e-20
C6964 a_1733_591# a_317_743# 2.33e-19
C6965 b4 a_469_1929# 1.66e-20
C6966 a_1125_3017# a_1692_4399# 1.19e-21
C6967 a_763_1256# a_1039_1942# 0.134961f
C6968 a5 a_1171_2045# 0.001096f
C6969 a_3827_6031# a_4180_6031# 2.18e-19
C6970 a_2375_3311# a_4073_4625# 2.87e-22
C6971 P7 a_1697_743# 1.73e-20
C6972 a_4636_3311# a_2375_4399# 4.29e-20
C6973 a_3523_3030# a_3609_4399# 5.81e-19
C6974 a_1329_6183# a_1907_5309# 1.13e-20
C6975 a_5081_2767# a_1697_743# 5.24e-20
C6976 a_3813_3543# a_3983_4520# 9.03e-19
C6977 a3 a_1788_4765# 1.79e-19
C6978 a_4667_957# a_4860_1367# 9.64e-19
C6979 a_2907_2223# a_3164_2223# 0.024045f
C6980 a_5575_6397# a_2520_6575# 0.001503f
C6981 a_2689_6031# a_2157_5719# 6.29e-20
C6982 b5 a_1692_4399# 0.070785f
C6983 a_5923_1135# a_1823_4943# 0.001315f
C6984 b2 a_4011_3133# 0.003303f
C6985 a_2520_3855# a_2417_4625# 1.23e-20
C6986 a_3164_2223# a_395_854# 4.56e-21
C6987 a_2551_2589# a_2520_3855# 0.005936f
C6988 b3 a_1907_4221# 1.76e-21
C6989 a_5219_6397# a_3537_6807# 4.01e-19
C6990 a_1079_4399# a_1435_4399# 0.009846f
C6991 a_3747_6575# b3 1.55e-19
C6992 a_4943_1653# a4 0.004319f
C6993 a_4839_4943# a_3905_5719# 2.02e-20
C6994 b0 a_537_5487# 9.63e-20
C6995 b1 a_1067_5487# 0.002326f
C6996 a_1421_2919# a_1631_3133# 0.012248f
C6997 a_2375_3311# a_1865_4013# 0.008437f
C6998 a_2327_3432# a_1823_3855# 0.019774f
C6999 a_757_6281# a_527_4943# 6.12e-19
C7000 b0 a_537_5853# 3.38e-19
C7001 b1 a_1067_5853# 9.76e-20
C7002 DVDD a_2263_957# 0.144781f
C7003 a2 a_3571_2767# 5.93e-20
C7004 a5 a_527_2223# 0.001804f
C7005 a_2980_5487# a_3983_5608# 0.001673f
C7006 a_3387_6031# a_2689_6031# 2.46e-20
C7007 a2 a_4031_5487# 0.032928f
C7008 a1 a_2417_4625# 0.062684f
C7009 a_1539_6397# DVDD 0.149763f
C7010 a_2467_2223# a_2244_2767# 0.917919f
C7011 a_995_4399# a_2244_2767# 1.19e-20
C7012 a_4268_2767# a_1692_4399# 8e-21
C7013 a_763_1256# a_1125_2767# 5.18e-20
C7014 a_3523_3030# a_3168_3311# 2.74e-20
C7015 a_995_4399# a_1733_5309# 1.56e-20
C7016 a_2327_3432# a4 0.103099f
C7017 a5 a_2688_3855# 2.35e-19
C7018 a_2263_6941# a_2520_6575# 0.024435f
C7019 a_1987_3133# a_573_4105# 0.103436f
C7020 a_757_6281# a_975_3311# 1.53e-20
C7021 a_627_5487# a_1733_6941# 7.97e-19
C7022 a_1823_6575# a_2263_6941# 0.030598f
C7023 a_3941_5853# a_3905_5719# 4.78e-19
C7024 a_4115_5853# a_2283_5487# 0.006108f
C7025 a_4471_5853# a_2235_5608# 0.003404f
C7026 a_527_2589# a_883_2589# 0.008475f
C7027 a_4103_6941# a_3517_5487# 0.036203f
C7028 a_3655_2767# a_3537_1367# 9.81e-21
C7029 a5 a_1697_743# 3.48e-21
C7030 a_4533_2449# a_6296_2767# 3.65e-20
C7031 b3 a_3609_4719# 6.37e-19
C7032 a_1697_743# a_3747_1135# 4.21e-19
C7033 DVDD a_1692_4399# 1.07809f
C7034 a_961_1831# a_1631_2767# 3.17e-20
C7035 a2 a_3655_3133# 1.4e-19
C7036 a_1733_3855# a_573_4105# 3.02e-21
C7037 a_1039_1942# a_1987_3133# 0.003858f
C7038 a_1823_4943# a_2367_5853# 2.28e-19
C7039 a_1497_6189# a_1907_6941# 2.77e-19
C7040 a_2980_5487# a_1329_6183# 4.86e-20
C7041 a_5002_1501# a_4860_1367# 0.007833f
C7042 a_3387_6031# a_3297_6397# 0.006823f
C7043 a_1775_854# a_1236_957# 3.18e-20
C7044 a_5575_6397# a_4031_5487# 2.32e-19
C7045 P6 a_5653_5095# 0.006787f
C7046 a_3332_2223# a_2341_2455# 4.03e-20
C7047 a_1784_1679# a_1987_2767# 6.43e-21
C7048 a1 a_4471_4399# 0.002284f
C7049 a_5587_3133# a_5503_2767# 0.030161f
C7050 b0 a_4252_6397# 3.02e-21
C7051 a_5943_3133# a_4031_5487# 1.23e-20
C7052 a_6020_4221# a_4031_5487# 4.95e-20
C7053 a0 a_2327_4520# 0.021772f
C7054 a3 a_2459_4399# 7.15e-19
C7055 a_995_4399# a_627_5487# 2.07e-20
C7056 a_1328_3677# a_409_3543# 5.43e-19
C7057 b5 a_5311_4221# 0.007038f
C7058 a_5311_3855# a_4031_5487# 0.017809f
C7059 a_3261_6183# a_481_6281# 4.47e-20
C7060 a_2045_2543# b3 1.29e-20
C7061 a_5413_3133# b5 4.34e-20
C7062 a_4457_743# a_1697_743# 0.166198f
C7063 a0 a_395_2344# 0.006775f
C7064 b1 a_2327_3432# 0.011418f
C7065 b0 a_297_3017# 1.03e-19
C7066 b5 a_4712_3855# 3.84e-20
C7067 a2 a_4471_5487# 0.004257f
C7068 a_3537_1367# a_3663_1135# 0.879001f
C7069 b2 a_3609_4399# 8.77e-21
C7070 a_3813_3543# a_2249_3543# 0.015191f
C7071 b2 a_1527_1679# 2.06e-20
C7072 a_5192_5309# a_4351_5206# 3.03e-19
C7073 a_2417_4625# a_2367_5487# 8.88e-21
C7074 a0 a_2193_5487# 1.27e-20
C7075 a_2327_4520# a_2723_5487# 4.55e-21
C7076 a_711_5487# a_1067_5487# 0.009846f
C7077 a_1455_6031# a_995_4399# 2.18e-20
C7078 a_1775_854# a_1604_1135# 6.26e-20
C7079 a_5002_1174# a_4860_1367# 0.005572f
C7080 a_4457_743# a_4493_957# 5.12e-20
C7081 a_501_5719# a_849_4105# 5.41e-22
C7082 a5 a_1907_4221# 6.45e-20
C7083 b5 a_4023_3677# 3.43e-21
C7084 a_4943_1653# a_5779_4943# 0.023618f
C7085 a_2520_3855# a_3148_1135# 8.49e-20
C7086 a3 a_1907_6941# 2.12e-20
C7087 a_4709_1929# a_5345_1929# 8.48e-20
C7088 a_4351_5206# a_5265_5807# 1.61e-19
C7089 a_2375_3311# a_1697_743# 1.03e-20
C7090 a_3537_1367# a_4103_1501# 0.055072f
C7091 a_4456_6941# P3 0.005587f
C7092 a_4268_2767# a_5311_4221# 2.26e-21
C7093 a_2520_6575# a_3905_5719# 3.19e-20
C7094 b2 a_3148_5853# 7.6e-20
C7095 a_711_5853# a_1067_5853# 0.008475f
C7096 a_3537_6807# a_2283_5487# 0.014465f
C7097 a_1823_6575# a_3905_5719# 4.96e-21
C7098 a_627_5487# a_2235_5608# 5.31e-20
C7099 a_2248_6031# a_1775_6696# 5.68e-20
C7100 a_2249_4631# a_2285_4765# 1.45e-19
C7101 a_2375_4399# a_1860_4765# 4.35e-20
C7102 a_3983_4520# a_1692_4399# 0.009787f
C7103 b4 a_3164_2223# 0.055273f
C7104 a_4728_4399# a_5227_3855# 1.24e-19
C7105 b0 a_5653_5095# 0.136946f
C7106 a_984_6183# a_248_4631# 4.56e-21
C7107 a_2467_2223# a_485_749# 1.18e-20
C7108 b4 a_3905_5719# 0.031176f
C7109 a_757_6281# a1 0.089568f
C7110 a_4709_1929# a_5227_3855# 3.23e-19
C7111 b2 a_3168_3311# 1.41e-19
C7112 DVDD a_5045_6397# 4.94e-19
C7113 a_4839_4943# a_2249_4631# 0.003154f
C7114 a_4636_3311# a_3072_4399# 5.01e-21
C7115 a_4471_4399# a_2417_4625# 1.02e-20
C7116 a_3523_3030# a_4399_4943# 1.39e-21
C7117 a_2235_1256# a_2723_1501# 0.011151f
C7118 a_2244_2767# a_2341_2455# 0.034746f
C7119 a_1769_2543# a_1508_1135# 1.21e-19
C7120 a_1455_6031# a_2235_5608# 6.59e-19
C7121 a_1497_6189# a_2283_5487# 0.025983f
C7122 DVDD a_5311_4221# 0.162119f
C7123 a_2467_2223# a_1125_3017# 0.302026f
C7124 a_1775_854# a_5503_2767# 1.92e-20
C7125 DVDD a_2285_4399# 4.94e-19
C7126 DVDD a_5413_3133# 4.94e-19
C7127 a_995_4399# a_1125_3017# 2.85e-20
C7128 a_3537_1367# a_4456_1135# 4.45e-20
C7129 a_3072_3311# a_5227_3855# 0.002221f
C7130 a2 a_5188_2223# 9.69e-20
C7131 a_553_1679# a_2244_2767# 0.013771f
C7132 a4 a_5873_2045# 2.18e-20
C7133 a2 a_2375_4399# 0.069751f
C7134 a_4896_5487# a_4351_5206# 0.008063f
C7135 b5 a_2467_2223# 1.67e-20
C7136 a_395_2344# a_883_2589# 0.00616f
C7137 a_2244_2767# a_2980_1135# 0.001609f
C7138 a_297_3017# a_685_1367# 2.9e-20
C7139 a_6296_3133# a_5545_2925# 1.51e-19
C7140 b5 a_995_4399# 0.02117f
C7141 P5 a_2249_4631# 1.95e-19
C7142 a_2263_4943# a_2688_4943# 8.12e-20
C7143 DVDD a_4023_3677# 0.035424f
C7144 a3 a_573_4105# 0.211886f
C7145 b4 a_3481_3133# 2.61e-20
C7146 a2 a_849_4105# 2.56e-21
C7147 a_1421_2919# a_1823_3855# 0.019764f
C7148 a_849_3017# a_1865_4013# 1.7e-19
C7149 a_2327_3432# a_2493_1929# 2.03e-20
C7150 a4 a_6412_4007# 3.35e-19
C7151 a_2340_3133# a_1775_4118# 2.42e-19
C7152 a_1784_1679# a_355_1653# 4e-20
C7153 DVDD a_1733_6941# 1.37e-20
C7154 a_2327_3432# a_2263_4221# 2.75e-20
C7155 P2 a_1329_6183# 0.002995f
C7156 a_3164_2223# a_3571_2767# 0.810861f
C7157 a_1907_4943# a_443_4943# 6.94e-21
C7158 a_2467_2223# a_4268_2767# 9.51e-21
C7159 a3 a_1039_1942# 0.017981f
C7160 a_4379_3311# a_4804_3311# 1.31e-19
C7161 a_995_4399# a_4268_2767# 9.95e-20
C7162 a4 a_1421_2919# 0.088941f
C7163 a_2459_3677# a_2815_3677# 0.008475f
C7164 a_5135_6031# a0 0.01833f
C7165 a_5009_6183# a_4483_5309# 5.59e-20
C7166 a_757_6281# a_2417_4625# 1.03e-20
C7167 a_4351_5206# a_3517_5807# 2.27e-21
C7168 a_409_3543# a_1508_1135# 0.00591f
C7169 a_3537_1367# a_4436_3133# 7.39e-21
C7170 a3 a_2283_5487# 0.049647f
C7171 a_2283_5487# a_6412_5719# 1.41e-20
C7172 a5 a_2045_2543# 6.33e-19
C7173 a_3905_5719# a_4031_5487# 0.696114f
C7174 b5 a_2235_5608# 1.8e-20
C7175 a4 a_443_4943# 2.16e-19
C7176 a_975_3677# a_1328_3677# 2.18e-19
C7177 b2 a_1401_3855# 1.16e-20
C7178 a_4943_1653# a_5284_2223# 3.96e-19
C7179 a_4457_743# a_4931_2223# 4.88e-19
C7180 b4 a_4115_5487# 3.42e-19
C7181 a_5575_6031# a_6000_6031# 8.12e-20
C7182 a_1697_743# a_2616_591# 5.43e-19
C7183 a_3983_5608# a_4073_4625# 6.98e-21
C7184 DVDD a_2467_2223# 1.01778f
C7185 a_5943_3133# a_5188_2223# 1.07e-19
C7186 a_3799_4118# a_4712_4221# 3.18e-19
C7187 a_4073_4625# a_5137_4221# 5.01e-20
C7188 a_2375_4399# a_6020_4221# 5.72e-19
C7189 a_4533_2449# a_4073_4625# 1.14e-21
C7190 a_2375_4399# a_2815_4399# 0.003858f
C7191 b3 a_317_2455# 0.087286f
C7192 DVDD a_995_4399# 1.9492f
C7193 a_5943_3133# a_2375_4399# 3.93e-20
C7194 b3 a_248_4631# 0.026819f
C7195 a_5923_1135# a_6403_1679# 0.001009f
C7196 P2 a_1037_4625# 2.29e-20
C7197 a_3799_4118# a_4287_3855# 0.006142f
C7198 a_2375_4399# a_5311_3855# 0.033252f
C7199 a_5075_1148# a_3663_1135# 0.065659f
C7200 DVDD a_4252_2045# 4.72e-19
C7201 a_527_591# a_883_591# 0.008475f
C7202 a_3571_2767# a_3481_3133# 0.006823f
C7203 a_3164_2223# a_3655_3133# 0.012115f
C7204 a5 a_895_1501# 6.2e-19
C7205 P11 a_2235_1256# 0.027068f
C7206 P8 a_5923_1135# 1.69e-19
C7207 b0 a_5863_4943# 9.77e-20
C7208 a3 a_1125_2767# 6.75e-20
C7209 a5 a_297_2767# 7.13e-20
C7210 a_627_5487# a_317_5095# 9.37e-19
C7211 a_849_4105# a_2815_4399# 8.82e-21
C7212 a_355_1653# a_975_3311# 1.83e-20
C7213 a_5587_2767# a_5545_2925# 0.033252f
C7214 a_2249_3543# a_1692_4399# 0.002225f
C7215 a_1676_1135# a_2980_1135# 4.13e-21
C7216 a_947_4520# a_975_3311# 7.58e-21
C7217 a_4544_3855# a_3847_3855# 0.049388f
C7218 b1 a_3241_4943# 1.48e-19
C7219 a_4533_2449# a_1865_4013# 0.016517f
C7220 a_1784_1679# a_1952_2045# 0.00769f
C7221 a_3757_3855# a_3847_3855# 0.006958f
C7222 a_3931_3855# a_3072_3311# 0.048663f
C7223 b2 a_4399_4943# 3.31e-19
C7224 a_4640_3855# a_1865_4013# 4.12e-19
C7225 a_3891_3432# a_5227_3855# 0.050672f
C7226 P3 a_3983_5608# 4.32e-19
C7227 a_4751_1831# a_4535_854# 0.042609f
C7228 a_6572_5309# a_2283_5487# 2.4e-21
C7229 a_5863_5309# a_4031_5487# 8.63e-19
C7230 b1 a_1421_2919# 8.72e-21
C7231 a_1455_6031# a_317_5095# 3e-22
C7232 a_2341_2455# a_485_749# 1.62e-21
C7233 b5 a_5264_5309# 3.07e-20
C7234 a_1775_4118# a_2193_1135# 0.006823f
C7235 DVDD a_1769_3631# 1.12e-19
C7236 a_3983_5608# a_5045_6031# 1.06e-19
C7237 a_2249_4631# a_1823_6575# 7.99e-19
C7238 a_4732_3311# a_4544_3855# 3.19e-19
C7239 a_1775_854# a_2688_957# 1.9e-19
C7240 b1 a_443_4943# 0.022063f
C7241 DVDD a_2235_5608# 0.930515f
C7242 a_3849_3677# a_1865_4013# 1.24e-19
C7243 a_3168_3677# a_3072_3311# 0.005539f
C7244 a_1775_4118# a_3747_1501# 4.59e-21
C7245 a_2551_2223# a_2235_1256# 4.79e-19
C7246 a_2781_2767# a4 1.69e-19
C7247 a_5873_2045# a_5779_4943# 4.01e-20
C7248 a_2327_3432# a_2327_4520# 0.00334f
C7249 a_1125_3017# a_2341_2455# 0.543516f
C7250 a_4804_3311# a_3891_3432# 3.98e-19
C7251 a_5503_2767# a_5545_2925# 0.235046f
C7252 a3 a_849_3855# 5.46e-19
C7253 a_4471_5487# a_3905_5719# 0.011819f
C7254 a_4625_749# a_6173_1455# 1.17e-19
C7255 a_4115_5487# a_4031_5487# 0.030161f
C7256 a_553_1679# a_485_749# 9.57e-20
C7257 b4 a_2249_4631# 0.150852f
C7258 a_1497_6189# a_1435_4765# 2.7e-21
C7259 a_2263_6575# a_2616_6575# 2.18e-19
C7260 a_395_2344# a_2327_3432# 1.21e-21
C7261 a_3847_3855# a_443_591# 5.08e-21
C7262 a_2520_6575# a_2723_5853# 5.9e-20
C7263 b5 a_2341_2455# 0.039727f
C7264 DVDD a_2325_1929# 0.008762f
C7265 a_2285_4765# a_1823_4943# 1.85e-19
C7266 a_1692_4399# a_5653_5095# 0.369198f
C7267 a_1697_743# a_849_3017# 8.38e-20
C7268 a_481_6031# a_481_6281# 0.009374f
C7269 a_6412_4007# a_5779_4943# 0.142411f
C7270 a_3523_3030# a_4351_5206# 9.85e-20
C7271 a_1125_3017# a_2980_1135# 3.37e-19
C7272 a_5503_2767# a_5923_1135# 8.52e-20
C7273 a_1775_854# a_5923_2223# 1.23e-20
C7274 a_3261_6183# b2 1.78e-20
C7275 a_2980_5487# a_481_6281# 0.001906f
C7276 a_4309_4943# a_4399_4943# 0.007184f
C7277 a_4483_4943# a_3072_4399# 0.041195f
C7278 a_1865_4013# a_4793_1679# 6.58e-19
C7279 a_4575_2589# a_4268_2767# 0.049907f
C7280 a_2325_5713# a_2263_4943# 1.95e-20
C7281 b3 a_1457_2767# 4.33e-20
C7282 a_995_4399# a_3983_4520# 0.005126f
C7283 a_2980_5487# a_3517_5807# 8.72e-20
C7284 a_961_1831# a_443_591# 4.36e-20
C7285 a_1631_3133# a_1508_1135# 0.008403f
C7286 a_1497_6189# a_2367_5853# 6e-20
C7287 a_5863_5309# a_6219_5309# 0.009846f
C7288 a0 a_1775_6696# 0.002888f
C7289 a_3537_6807# a_3827_6031# 0.023425f
C7290 a2 a_3072_4399# 0.042977f
C7291 a_4268_2767# a_2341_2455# 0.086167f
C7292 a_1527_1679# a_573_4105# 5.02e-21
C7293 a_5009_6183# a5 9.1e-22
C7294 a_2045_2223# a_1865_4013# 1.79e-20
C7295 a_1895_6031# a_2320_6031# 8.12e-20
C7296 b5 a_317_5095# 0.004071f
C7297 P5 a_1823_4943# 0.047642f
C7298 a_6173_2543# a_2341_2455# 7.32e-21
C7299 b0 a_6277_4719# 6.76e-21
C7300 DVDD a_5264_5309# 4.72e-19
C7301 DVDD a_4575_2589# 0.001444f
C7302 a_1037_4625# a_1865_4013# 0.004816f
C7303 a_3537_1367# a_1865_749# 0.002118f
C7304 b0 a_409_3543# 0.00578f
C7305 a_4180_2045# a_1865_4013# 6.26e-20
C7306 a_2375_3311# a_4011_2767# 0.045338f
C7307 b1 a_1788_4399# 6.03e-20
C7308 a3 a_1435_4765# 4.63e-19
C7309 a_2375_4399# a_3164_2223# 1.13e-20
C7310 a_4268_2767# a_2980_1135# 6.47e-22
C7311 a_1455_6031# a_3471_6031# 0.033252f
C7312 a_4287_4221# a_4640_4221# 2.18e-19
C7313 a5 a_317_2455# 0.012308f
C7314 a_1527_1679# a_1039_1942# 0.005557f
C7315 a_2815_3677# a_2249_4631# 8.12e-20
C7316 a_2375_4399# a_3905_5719# 1.18e-20
C7317 a_3609_4399# a_2283_5487# 3.26e-19
C7318 a_3983_4520# a_2235_5608# 9.98e-21
C7319 a1 a_947_4520# 0.06939f
C7320 a5 a_248_4631# 0.291705f
C7321 a_2249_4631# a_4031_5487# 0.022419f
C7322 DVDD a_2341_2455# 1.04304f
C7323 a_4115_5487# a_4471_5487# 0.009846f
C7324 a_2493_1929# a_1421_2919# 3.65e-20
C7325 a_3891_3432# a_3931_3855# 2e-20
C7326 a_6173_1135# a_3663_1135# 0.060599f
C7327 a4 a_3537_1367# 1.72e-19
C7328 a_1421_2919# a_2263_4221# 2.22e-21
C7329 a_849_3017# a_1907_4221# 2.51e-20
C7330 b5 a_573_3855# 1.99e-19
C7331 a_2459_3677# a_849_4105# 0.036528f
C7332 a1 a_5227_3855# 0.001139f
C7333 b0 a_2157_5719# 0.081328f
C7334 a_4533_2449# a_1697_743# 0.01271f
C7335 DVDD a_553_1679# 1.0325f
C7336 a_4728_4399# a_4824_4765# 0.005587f
C7337 DVDD a_2980_1135# 1.54423f
C7338 a_1365_6031# a_1329_6183# 6.46e-20
C7339 b1 a_1401_6895# 2.9e-19
C7340 a_3517_5487# a_4839_5309# 9.07e-21
C7341 a_711_5487# a_443_4943# 0.038055f
C7342 a_3148_5853# a_2283_5487# 2.97e-19
C7343 a_317_743# a_2193_1135# 2.14e-20
C7344 a_2325_5713# a_1895_6031# 4.67e-20
C7345 a_711_5853# a_443_4943# 0.018495f
C7346 a_6092_4221# a_1823_4943# 2.11e-20
C7347 a_5667_4221# a_4399_4943# 1.77e-20
C7348 DVDD a_317_5095# 1.13343f
C7349 a_2815_4399# a_3072_4399# 0.024013f
C7350 a_5837_1831# a_1823_4943# 0.489175f
C7351 a_3387_6031# b0 0.031793f
C7352 a_3847_3855# a_4471_4765# 5.66e-22
C7353 a_5667_3855# a_1823_4943# 0.002798f
C7354 a_1328_3677# a4 3.56e-19
C7355 a_763_1256# a_395_854# 0.00518f
C7356 a_219_1929# a_485_749# 3.52e-20
C7357 a_6005_2223# a_3847_3855# 2.56e-20
C7358 a_2907_2223# a_3260_2223# 2.18e-19
C7359 a_5284_2589# a_5188_2223# 0.005644f
C7360 a_883_2223# a_355_1653# 0.004521f
C7361 a_1236_2223# a_317_2455# 5.89e-20
C7362 a_2375_4399# a_5863_5309# 0.001396f
C7363 a_4839_4943# a_5192_4943# 2.18e-19
C7364 DVDD a_1079_4765# 0.001506f
C7365 a_685_1367# a_409_3543# 2.56e-20
C7366 b2 a_4351_5206# 8.33e-20
C7367 a3 a_1079_4399# 3.5e-19
C7368 a_3523_3030# a_3747_1501# 1.91e-20
C7369 b3 a_4728_4399# 7.34e-21
C7370 a_4751_1831# a_5345_1679# 1.45e-21
C7371 a_1697_743# a_4793_1679# 3.53e-19
C7372 a_947_4520# a_2417_4625# 2.18e-20
C7373 a_4847_1653# a_4877_1679# 0.006719f
C7374 a_2467_2223# a_2249_3543# 1.09e-19
C7375 b4 a_2243_1929# 1.63e-20
C7376 a_219_1929# b5 1.64e-19
C7377 a_259_1831# a4 2.43e-20
C7378 a5 a_1457_2767# 3.7e-19
C7379 DVDD a_573_3855# 1.04e-19
C7380 a_995_4399# a_2249_3543# 0.029429f
C7381 a_297_3017# a_995_4399# 2.3e-20
C7382 a_5923_2223# a_5545_2925# 7.13e-19
C7383 a_481_6281# P2 0.028796f
C7384 a2 a_5264_4943# 3.09e-19
C7385 a_3983_4520# a_2341_2455# 7.46e-21
C7386 a_3571_2767# a_4103_1135# 0.005326f
C7387 b2 a_2340_3133# 6.03e-20
C7388 a0 a_3847_3855# 1.63e-20
C7389 a_4401_2589# a_1865_4013# 9e-21
C7390 a_1823_6575# a_1823_4943# 0.216425f
C7391 b3 a_3072_3311# 2.07e-19
C7392 b2 a_1907_5309# 0.001254f
C7393 P11 a_2244_2767# 0.041528f
C7394 a_1401_3855# a_573_4105# 3.92e-21
C7395 a0 a_2616_4943# 1.43e-19
C7396 a_3241_4943# a_2327_4520# 0.009921f
C7397 a_4751_1831# a_1775_854# 0.073368f
C7398 a_4847_1653# a_2467_2223# 1.5e-20
C7399 a_6047_1679# a_1823_4943# 0.033252f
C7400 a_1697_743# a_2045_2223# 0.006461f
C7401 a_5095_1929# a_5345_1929# 0.025037f
C7402 a_5923_2223# a_5923_1135# 9.91e-19
C7403 a_2263_3855# a_573_4105# 1.56e-20
C7404 b4 a_1823_4943# 0.035027f
C7405 a_3827_1679# a_4252_1679# 8.12e-20
C7406 a_1697_743# a_4180_2045# 9.8e-20
C7407 a_1421_2919# a_2327_4520# 8.58e-22
C7408 a_5173_3631# a_1865_4013# 1.45e-20
C7409 a_3827_6397# a_3905_5719# 3.72e-20
C7410 a_4252_6397# a_2235_5608# 1.74e-21
C7411 b0 a_975_3677# 5.76e-19
C7412 a_4180_6397# a_2283_5487# 6.9e-20
C7413 a0 a_961_1831# 9.85e-19
C7414 b1 a_1328_3677# 2.01e-19
C7415 a_5095_1929# a_5227_3855# 5.22e-19
C7416 a_4625_749# a_3847_3855# 1.49e-21
C7417 a_395_2344# a_1421_2919# 4.59e-20
C7418 a_4636_3311# b5 0.142004f
C7419 a_573_4105# a_721_1501# 1.88e-21
C7420 a1 a_3931_3855# 2.93e-20
C7421 a_4728_4399# a_4896_4399# 0.007708f
C7422 DVDD a_3471_6031# 0.001386f
C7423 a_995_4399# a_5653_5095# 9.86e-21
C7424 a_353_957# a_443_591# 0.006823f
C7425 P7 a_4709_1929# 0.00142f
C7426 a_2616_6575# a_2520_6575# 0.005046f
C7427 a_297_2767# a_297_4105# 2.58e-19
C7428 a_1865_749# a_5075_1148# 8e-20
C7429 a_2551_2223# a_2244_2767# 0.009242f
C7430 a_1865_4013# a_5289_1433# 2.11e-20
C7431 a4 a_1400_3311# 2.09e-19
C7432 b1 a_4896_4765# 9.67e-20
C7433 a_2325_5713# a_2520_3855# 1.38e-19
C7434 a_5376_591# a_4709_1929# 5.46e-20
C7435 a_3537_1367# a_3471_1679# 1.82e-19
C7436 a_2616_6575# a_1823_6575# 4.35e-21
C7437 a_2235_1256# a_3164_2223# 1.23e-19
C7438 DVDD a_219_1929# 0.18908f
C7439 b3 a_1784_1679# 4.79e-19
C7440 a_1865_4013# a_1775_4118# 0.741268f
C7441 a_1823_3855# a_1508_1135# 0.708895f
C7442 a_4931_2223# a_4533_2449# 0.083083f
C7443 a_2249_4631# a_2375_4399# 1.93677f
C7444 a_501_5719# a_627_5487# 0.870641f
C7445 a4 a_5075_1148# 4.24e-19
C7446 a_1455_6031# a_1907_6575# 3.27e-19
C7447 a_1907_4943# a_1508_1135# 7.5e-21
C7448 a_3813_3543# a_4436_3133# 1.66e-19
C7449 a_4636_3311# a_4268_2767# 3.66e-20
C7450 a_3523_3030# a_4364_3133# 3.03e-19
C7451 a_1308_4943# a_317_5095# 7.66e-19
C7452 a_6173_2223# a_3891_3432# 2.9e-19
C7453 a_527_4943# a_883_4943# 0.008475f
C7454 a_501_5719# a_2320_6397# 0.007578f
C7455 a_3571_2767# a_1823_4943# 3.38e-20
C7456 a_2325_5713# a1 0.111137f
C7457 a_3164_2223# a_3072_4399# 2.1e-20
C7458 a_757_6031# a5 2.21e-19
C7459 a_995_4399# a_1733_4221# 9.76e-20
C7460 a_1037_4625# a_1907_4221# 2.47e-19
C7461 a_2249_4631# a_849_4105# 2.98e-19
C7462 a_4399_4943# a_2283_5487# 0.266364f
C7463 a_3072_4399# a_3905_5719# 0.024104f
C7464 a_1823_4943# a_4031_5487# 0.072016f
C7465 a_2493_1929# a_3537_1367# 3.43e-20
C7466 a4 a_1508_1135# 0.133187f
C7467 a_2980_5487# b2 0.001387f
C7468 a_1455_6031# a_501_5719# 0.553219f
C7469 a_2520_3855# a_2688_4221# 0.00769f
C7470 a2 a_5265_4719# 2e-19
C7471 b1 a_4839_5309# 0.017965f
C7472 a_2157_5719# a_1692_4399# 2.78e-22
C7473 a_2375_4399# a_2723_5853# 6.12e-21
C7474 a0 a_4544_3855# 9.59e-20
C7475 DVDD a_4636_3311# 0.455059f
C7476 a5 a_4728_4399# 8.52e-20
C7477 a_1823_6575# a_2459_4765# 1.19e-19
C7478 a_961_1831# a_883_2589# 3.5e-20
C7479 a_317_743# a_1308_957# 1.13e-19
C7480 a_485_749# a_883_957# 0.080166f
C7481 a_395_854# a_1236_957# 5.13e-19
C7482 a_5219_6397# a_4351_5206# 1.82e-21
C7483 a_3983_5608# a_4896_5853# 2.57e-20
C7484 a5 a_4709_1929# 4.06e-22
C7485 b3 a_3891_3432# 7.6e-20
C7486 b1 a_3148_5487# 3.94e-20
C7487 b4 a_763_1256# 6.49e-19
C7488 a_757_6281# a_947_4520# 0.788002f
C7489 a_4709_1929# a_3747_1135# 1.5e-20
C7490 a_1527_2045# a_1508_1135# 0.004791f
C7491 a_4483_4943# a_627_5487# 5.51e-21
C7492 a_2249_4631# a_2815_3311# 1.64e-21
C7493 b3 a_975_3311# 0.003883f
C7494 a_2341_2455# a_2249_3543# 3.86e-20
C7495 a_2723_5853# a_3076_5853# 2.18e-19
C7496 a_984_6183# a1 3e-19
C7497 a_3387_6031# a_1692_4399# 3.3e-21
C7498 DVDD a_2723_1501# 0.046154f
C7499 a_763_1256# a_1251_1135# 0.017703f
C7500 a5 a_3072_3311# 0.079315f
C7501 a_4625_749# a_4544_3855# 1.81e-21
C7502 P9 a_317_743# 0.12592f
C7503 a_259_1831# a_527_2589# 7.76e-20
C7504 a_3261_6183# a_2283_5487# 0.00235f
C7505 a_553_1679# a_2249_3543# 2.43e-21
C7506 a2 a_627_5487# 0.014237f
C7507 a_297_3017# a_553_1679# 4.72e-21
C7508 a_975_3311# a_1328_3311# 2.18e-19
C7509 b0 a_3517_5487# 0.080221f
C7510 a_4493_591# a_395_854# 1.45e-20
C7511 a_4401_2223# a_1775_854# 0.006823f
C7512 a_2243_1929# a_2459_3311# 9.36e-21
C7513 a_4847_1653# a_2341_2455# 0.002249f
C7514 a_4751_1831# a_5545_2925# 7.27e-20
C7515 a_5689_5309# a_4399_4943# 6.07e-20
C7516 a_2320_6397# a2 3.45e-19
C7517 a_2325_5713# a_2417_4625# 2.52e-19
C7518 a_317_2455# a_297_4105# 0.05502f
C7519 a_961_1831# a_1907_957# 2.43e-20
C7520 a_4457_743# a_4709_1929# 0.102186f
C7521 b1 a_1508_1135# 0.023256f
C7522 a_501_5719# b5 6.64e-20
C7523 a_248_4631# a_297_4105# 0.03669f
C7524 a_4943_1653# a_5177_1929# 5.82e-20
C7525 a_4709_1929# a_6005_1135# 4.22e-20
C7526 a_1952_1679# a_317_743# 5.13e-20
C7527 a_1455_6031# a2 0.028856f
C7528 a_4805_2767# a_4544_3855# 3.19e-19
C7529 a_5943_3133# a_6368_3133# 1.31e-19
C7530 a_5837_1831# a_6296_3133# 0.004869f
C7531 a_4544_3855# a_4824_4399# 7.34e-20
C7532 a_3072_4399# a_4115_5487# 6.74e-19
C7533 a_1697_743# a_5289_1433# 0.006284f
C7534 a_4751_1831# a_5923_1135# 0.205192f
C7535 a_4625_749# a_443_591# 0.102476f
C7536 a_2325_5713# a_2367_5487# 0.097263f
C7537 a_2688_3855# a_1775_4118# 2.57e-20
C7538 a_5545_2925# a_4399_4943# 2.16e-21
C7539 a_2459_3311# a_1823_4943# 1.53e-20
C7540 a_317_2455# a_849_3017# 7.26e-20
C7541 a_5667_3855# a_6020_3855# 2.18e-19
C7542 a_4943_1653# a_3847_3855# 0.092898f
C7543 b0 a_3799_4118# 1.03e-20
C7544 a_2045_2543# a_2045_2223# 0.009374f
C7545 a5 a_1784_1679# 0.00161f
C7546 a_3523_3030# a_4073_4625# 8.07e-20
C7547 a_3813_3543# a_3799_4118# 0.021786f
C7548 a_4636_3311# a_3983_4520# 2.43e-20
C7549 a_1697_743# a_1775_4118# 0.168287f
C7550 a_2551_2223# a_1125_3017# 0.089637f
C7551 a3 a_2285_4765# 1.59e-19
C7552 a_3332_2223# a_3164_2223# 0.007718f
C7553 a_6000_6397# a_2520_6575# 9.76e-20
C7554 b2 a_4364_3133# 1.15e-19
C7555 a_5075_1148# a_5779_4943# 9.2e-19
C7556 a_1823_6575# a_1308_5309# 2.45e-20
C7557 a_2244_2767# a_2616_957# 3e-20
C7558 a_4103_6941# a_1775_6696# 0.030528f
C7559 b3 a_2520_3855# 1.88e-20
C7560 DVDD a_883_957# 0.153614f
C7561 b0 a_1823_3855# 2.03e-20
C7562 b4 a_1987_3133# 0.003298f
C7563 a_1907_6575# DVDD 0.161936f
C7564 b1 a_1492_5487# 2.77e-19
C7565 a_2375_3311# a_3072_3311# 0.059589f
C7566 a_3523_3030# a_1865_4013# 0.04368f
C7567 a_2327_3432# a_3847_3855# 9.26e-22
C7568 a_961_1831# a_883_591# 1.52e-21
C7569 a1 a_883_4943# 0.005349f
C7570 a_3261_6183# a_3941_5487# 6.29e-21
C7571 a5 a_527_4943# 9.66e-21
C7572 b1 a_1492_5853# 3.53e-19
C7573 a_1733_4943# P1 7.56e-20
C7574 a_5837_1831# a_6403_1679# 0.046765f
C7575 a_5009_6183# a_3983_5608# 0.00118f
C7576 a_501_5719# DVDD 0.649683f
C7577 b0 a4 0.257195f
C7578 DVDD P11 0.101459f
C7579 a3 P5 0.077701f
C7580 a2 b5 1.02063f
C7581 a_5023_591# P7 0.023012f
C7582 a1 b3 0.412471f
C7583 a_469_1929# a_485_749# 2.53e-20
C7584 a_1171_2045# a_317_743# 4.34e-19
C7585 b0 a_5219_6031# 0.001992f
C7586 a_3813_3543# a_4023_3311# 0.011205f
C7587 a_2243_1929# a_849_4105# 2.86e-20
C7588 a_3523_3030# a_3849_3311# 0.006905f
C7589 a_3813_3543# a4 0.012856f
C7590 a_5023_591# a_5376_591# 2.18e-19
C7591 a_395_2344# a_1328_3677# 3.73e-20
C7592 a_2327_3432# a_961_1831# 4.3e-20
C7593 a_5188_2223# a_1823_4943# 0.016961f
C7594 a5 a_3891_3432# 0.325969f
C7595 a_2520_6575# a_2616_6941# 0.005743f
C7596 a_2263_6941# a_2688_6941# 8.12e-20
C7597 a_259_1831# a_527_591# 2.01e-20
C7598 a_2249_4631# a_3072_4399# 0.142384f
C7599 a_2375_4399# a_1823_4943# 0.098645f
C7600 a_3655_2767# a_2467_2223# 7.59e-20
C7601 a5 a_975_3311# 0.001991f
C7602 b2 a_619_3311# 3.57e-19
C7603 a_1823_6575# a_2616_6941# 2.93e-20
C7604 a_627_5487# a_2263_6941# 0.036715f
C7605 a_3537_6807# a_2520_6575# 0.001366f
C7606 a_5837_1831# a_5587_2767# 2.97e-19
C7607 a_4471_5853# a_3905_5719# 0.044609f
C7608 a_4824_5853# a_2235_5608# 1.28e-19
C7609 a_4115_5853# a_4031_5487# 0.066185f
C7610 a_4528_6941# a_3517_5487# 0.00111f
C7611 a_4351_5206# a_2283_5487# 0.779761f
C7612 a_4364_2767# a_3537_1367# 6.67e-20
C7613 a_995_4399# a_409_3543# 6.03e-21
C7614 a_1907_4221# a_1775_4118# 0.025034f
C7615 b3 a_4115_4765# 2.4e-19
C7616 a_2263_4221# a_1508_1135# 0.011819f
C7617 a_849_4105# a_1823_4943# 1.67e-19
C7618 a_1421_2919# a_1631_2767# 0.047849f
C7619 a4 a_2193_1501# 1.88e-22
C7620 a_961_1831# a_1604_1501# 1.97e-19
C7621 a2 a_4268_2767# 8.36e-20
C7622 a_1039_1942# a_2340_3133# 4.35e-21
C7623 a_259_1831# a_395_2344# 0.001839f
C7624 a_3164_2223# a_2244_2767# 0.001525f
C7625 DVDD a_2551_2223# 0.162129f
C7626 a_6047_1679# a_6403_1679# 0.008475f
C7627 a_2248_6397# a_1823_6575# 1.59e-19
C7628 b4 a_3537_6807# 0.049326f
C7629 DVDD a_4483_4943# 0.001438f
C7630 a_2459_3677# a_2244_2767# 1.77e-19
C7631 a_4943_1653# a_4544_3855# 2.83e-19
C7632 a_2263_5309# a_2235_5608# 4.15e-19
C7633 a1 a_527_5309# 0.008978f
C7634 a_1497_6189# a_1823_6575# 0.157716f
C7635 a_5223_1501# a_443_591# 0.005081f
C7636 a_757_6281# a_2325_5713# 9.62e-21
C7637 a_4575_2223# a_2341_2455# 0.003934f
C7638 P6 a_5779_4943# 6.02e-21
C7639 a_4457_743# a_3891_3432# 0.001607f
C7640 a_995_4399# a_2157_5719# 9.83e-22
C7641 a1 a_4896_4399# 4.22e-20
C7642 a_5837_1831# a_5503_2767# 0.079781f
C7643 a_883_2223# b3 3.32e-19
C7644 DVDD a2 1.69774f
C7645 b1 b0 0.330206f
C7646 a_2467_2223# a_3663_1135# 0.003215f
C7647 b3 a_2417_4625# 0.102052f
C7648 a_2551_2589# b3 4.37e-20
C7649 a_6020_3855# a_4031_5487# 7.33e-20
C7650 a4 a_685_1367# 3.08e-19
C7651 b5 a_5311_3855# 0.005784f
C7652 a_1697_743# a_317_743# 0.121681f
C7653 a_1251_1135# a_1604_1135# 2.18e-19
C7654 b2 a_4073_4625# 1.39e-19
C7655 a_4457_743# a_4860_1367# 0.007086f
C7656 a_4943_1653# a_443_591# 1.88e-20
C7657 a_2045_2223# a_2723_1135# 1.01e-20
C7658 a_1775_854# a_2193_1135# 6.84e-20
C7659 a_2375_3311# a_3891_3432# 0.009884f
C7660 a_5319_1174# a_443_591# 4.21e-19
C7661 a_1769_2543# a_2341_2455# 1.87e-21
C7662 a_883_591# a_443_591# 0.043319f
C7663 a_4667_591# a_4535_854# 0.017809f
C7664 a_2467_2223# a_4103_1501# 1.55e-19
C7665 a_1775_854# a_3747_1501# 0.001097f
C7666 a5 a_2520_3855# 0.038418f
C7667 a_395_2344# a_1400_3311# 5.25e-21
C7668 a_757_6281# a_984_6183# 0.184182f
C7669 a_2263_957# a_1865_749# 0.080942f
C7670 a_2616_957# a_485_749# 4.35e-21
C7671 a_2688_957# a_395_854# 4.68e-19
C7672 DVDD a_469_1929# 0.261972f
C7673 a_6173_1135# a_5779_4943# 2.12e-19
C7674 a_1823_3855# a_2263_957# 3.68e-20
C7675 a_4457_743# P10 6.72e-20
C7676 b2 a_1865_4013# 0.106873f
C7677 a_2157_5719# a_2235_5608# 0.811318f
C7678 a_317_2455# a_2045_2223# 2.73e-19
C7679 a_1527_2045# a_685_1367# 4.65e-20
C7680 a3 a_2520_6575# 0.030509f
C7681 a_3523_3030# a_1697_743# 2.49e-20
C7682 a_2520_6575# a_6412_5719# 0.01368f
C7683 a_3537_1367# a_4528_1501# 3.29e-19
C7684 a_501_5719# a_537_5487# 5.12e-20
C7685 a_4073_4625# a_4535_854# 2.11e-20
C7686 a_2412_2767# a_1987_2767# 8.12e-20
C7687 b2 a_1733_4943# 3.07e-19
C7688 a_5023_591# a_4457_743# 0.046513f
C7689 a_5503_2767# a_6047_1679# 2.36e-19
C7690 a_4268_2767# a_5311_3855# 3.31e-21
C7691 a_3537_6807# a_4031_5487# 1.91e-19
C7692 a_627_5487# a_3905_5719# 6.74e-19
C7693 a3 a_1823_6575# 0.0086f
C7694 a_248_4631# a_1037_4625# 9.43e-20
C7695 a_2249_4631# a_2815_4765# 0.053287f
C7696 b4 a_5503_2767# 5.51e-19
C7697 a_3799_4118# a_1692_4399# 0.049029f
C7698 a_501_5719# a_537_5853# 6.46e-20
C7699 a_3261_6183# a_3827_6031# 0.046469f
C7700 a_2375_4399# a_2459_4765# 0.062682f
C7701 a_763_1256# a_1171_1679# 0.072173f
C7702 a1 a5 0.071814f
C7703 b0 a_5779_4943# 0.029855f
C7704 a3 b4 0.185489f
C7705 DVDD a_5575_6397# 0.248569f
C7706 a_5177_1929# a_6412_4007# 6.07e-20
C7707 b2 a_3849_3311# 5.01e-20
C7708 a_5345_1929# a_5227_3855# 2.11e-19
C7709 a_5192_4943# a_2375_4399# 6.49e-20
C7710 a_4483_4943# a_3983_4520# 6.52e-20
C7711 a_4839_4943# a_3609_4399# 1.75e-19
C7712 a_1508_1135# a_2327_4520# 0.004251f
C7713 a_3813_3543# a_5779_4943# 3.99e-20
C7714 a_849_4105# a_2459_4765# 1.68e-20
C7715 a_1697_743# a_2367_1501# 0.011569f
C7716 a_2235_1256# a_3148_1501# 6.11e-20
C7717 a_1455_6031# a_3905_5719# 0.00594f
C7718 a_3387_6031# a_2235_5608# 0.006271f
C7719 a_4535_854# a_1865_4013# 0.102348f
C7720 a_2980_5487# a_2283_5487# 0.094691f
C7721 a_2243_1929# a_2235_1256# 0.022339f
C7722 DVDD a_5943_3133# 0.144974f
C7723 DVDD a_6020_4221# 4.94e-19
C7724 a_395_2344# a_1508_1135# 5.49e-20
C7725 DVDD a_2815_4399# 0.155402f
C7726 a_4457_743# a_2520_3855# 1.97e-20
C7727 a_1823_3855# a_1692_4399# 7.19e-19
C7728 a_995_4399# a_1631_3133# 1.22e-19
C7729 DVDD a_5311_3855# 0.001386f
C7730 b1 a_685_1367# 8.03e-20
C7731 a_5413_2767# a_5503_2767# 0.006958f
C7732 a_1907_4943# a_1692_4399# 7.2e-20
C7733 a2 a_3983_4520# 0.028882f
C7734 a_3655_2767# a_2341_2455# 0.002952f
C7735 a_1907_591# a_317_743# 0.004662f
C7736 a_1308_591# a_485_749# 4.35e-20
C7737 b4 a_997_2045# 5.56e-21
C7738 a_5587_2767# a_4031_5487# 2.51e-20
C7739 a5 a_5356_2223# 2.21e-20
C7740 P7 a_5095_1929# 1.75e-19
C7741 a_1775_4118# a_895_1501# 5.86e-21
C7742 b4 a_4011_3133# 0.004008f
C7743 a4 a_1692_4399# 0.0232f
C7744 a_1401_6895# a_1775_6696# 4.48e-20
C7745 a_4103_6575# b0 0.001897f
C7746 a_553_1679# a_409_3543# 3.76e-21
C7747 a_2375_3311# a_2520_3855# 0.024265f
C7748 DVDD a_2263_6941# 8.16e-19
C7749 b0 a_711_5487# 2.82e-19
C7750 a0 a_1067_5487# 0.002286f
C7751 a_3164_2223# a_1125_3017# 0.063113f
C7752 a_395_2344# a_527_957# 4.98e-21
C7753 a_1039_1942# a_1457_3133# 0.006823f
C7754 a5 a_883_2223# 0.002369f
C7755 a_2459_3677# a_1125_3017# 8.62e-22
C7756 b0 a_711_5853# 0.001737f
C7757 a_1823_4943# a_3072_4399# 0.001357f
C7758 a_757_6281# a_883_4943# 0.006874f
C7759 a0 a_1067_5853# 7.03e-19
C7760 DVDD a_5873_1679# 2.78e-19
C7761 a_5503_2767# a_4031_5487# 5.83e-20
C7762 DVDD a_2616_957# 2.76e-19
C7763 a_4471_4399# a_4896_4399# 1.31e-19
C7764 b5 a_3164_2223# 5.61e-19
C7765 a_6403_2045# a_1823_4943# 0.084462f
C7766 a_5009_6183# a_5192_5309# 0.005002f
C7767 a_961_1831# a_1421_2919# 0.027046f
C7768 a_4031_5487# a_6412_5719# 1.05e-19
C7769 a3 a_4031_5487# 2.62e-20
C7770 a_1539_6397# b1 0.003028f
C7771 a5 a_2551_2589# 3.23e-20
C7772 a5 a_2417_4625# 0.005726f
C7773 a_409_3543# a_317_5095# 6.11e-21
C7774 a_757_6281# b3 0.160571f
C7775 a1 a_2375_3311# 8.6e-20
C7776 a_2341_2455# a_3663_1135# 1.13e-19
C7777 b4 a_4824_5487# 1.61e-21
C7778 a_4943_1653# a_6005_2223# 0.003672f
C7779 a_4457_743# a_5356_2223# 2.92e-19
C7780 a_1455_6031# a_4115_5487# 8.87e-20
C7781 a_5837_1831# a_5923_2223# 0.002357f
C7782 a_1079_4765# a_409_3543# 2.43e-21
C7783 a_4073_4625# a_5667_4221# 0.001019f
C7784 a_1784_1679# a_849_3017# 3.87e-20
C7785 a_2249_4631# a_5265_4719# 3.24e-19
C7786 a_2980_1135# a_3663_1135# 0.518569f
C7787 a_3799_4118# a_4712_3855# 2.57e-20
C7788 b2 a_1697_743# 1.36e-20
C7789 a_4533_2449# a_4709_1929# 2.78e-20
C7790 a5 a_5095_1929# 3.81e-22
C7791 a_6047_2045# a_3891_3432# 4.2e-19
C7792 a_3571_2767# a_4011_3133# 0.004259f
C7793 a_3164_2223# a_4268_2767# 0.15225f
C7794 b1 a_1692_4399# 0.681631f
C7795 a_1733_3855# a_849_4105# 7.6e-19
C7796 a_3931_4221# a_1692_4399# 0.00409f
C7797 a_553_1679# a_2367_1135# 1.61e-19
C7798 a_2367_1135# a_2980_1135# 2.75e-19
C7799 b1 a_3977_4943# 2.79e-19
C7800 a_3799_4118# a_4023_3677# 6.48e-19
C7801 a_4544_3855# a_6412_4007# 0.006836f
C7802 a_4073_4625# a_4379_3677# 4.82e-19
C7803 a_1865_4013# a_2459_4399# 1.49e-19
C7804 a_4533_2449# a_3072_3311# 2.8e-21
C7805 a_2551_2223# a_2249_3543# 2.27e-21
C7806 a_883_2223# a_1236_2223# 2.18e-19
C7807 a_1775_854# a_1308_957# 3.68e-20
C7808 a_4103_1501# a_2980_1135# 5.49e-20
C7809 a_4640_3855# a_3072_3311# 5.43e-19
C7810 a_4287_3855# a_3847_3855# 0.03546f
C7811 a_1697_743# a_4535_854# 0.039567f
C7812 a_6219_5309# a_6412_5719# 0.024478f
C7813 DVDD a_3164_2223# 0.945469f
C7814 a_619_3311# a_573_4105# 0.007087f
C7815 a_763_1256# a_2235_1256# 0.006107f
C7816 a1 a_3471_6397# 0.002882f
C7817 a_5284_2589# b5 2.2e-19
C7818 a_1775_4118# a_2723_1135# 0.003858f
C7819 DVDD a_2459_3677# 0.001386f
C7820 a_4533_2449# a_4379_3311# 5.59e-20
C7821 a_1308_2223# a_395_2344# 1.9e-19
C7822 DVDD a_3905_5719# 1.30536f
C7823 a_2340_2767# a_1421_2919# 5.43e-19
C7824 a_5188_2223# a_6403_1679# 3.26e-20
C7825 a_4943_1653# a_4625_749# 8.2e-20
C7826 a_4457_743# a_5095_1929# 0.012283f
C7827 a_5413_3133# a4 3.02e-20
C7828 a_4379_3677# a_1865_4013# 0.009569f
C7829 a_3849_3677# a_3072_3311# 9.61e-19
C7830 a_2377_2223# a_1697_743# 2.27e-20
C7831 a_4625_749# a_5319_1174# 3.28e-19
C7832 a_2375_3311# a_2417_4625# 9.23e-20
C7833 b0 a_395_2344# 2.74e-19
C7834 a0 a_2327_3432# 2.08e-20
C7835 a_4535_854# a_4493_957# 1.96e-20
C7836 P9 a_1775_854# 9.21e-19
C7837 a_4824_5487# a_4031_5487# 4.35e-21
C7838 b4 a_3609_4399# 0.102357f
C7839 a_317_2455# a_1775_4118# 1.42e-20
C7840 a_317_743# a_895_1501# 8.91e-19
C7841 a_4709_1929# a_4793_1679# 7.44e-19
C7842 a_3655_3133# a_4011_3133# 0.009846f
C7843 a_4535_854# a_5821_5101# 4.56e-21
C7844 b0 a_2193_5487# 8.67e-21
C7845 a_1455_6031# a_2249_4631# 6.52e-21
C7846 a_6173_1455# a_5075_1148# 0.003019f
C7847 a_1692_4399# a_5779_4943# 0.028663f
C7848 a_2815_4765# a_1823_4943# 7.88e-19
C7849 a_2263_4943# a_1329_6183# 2.76e-21
C7850 a_4457_743# a_4667_957# 0.011205f
C7851 a_2244_2767# a_4103_1135# 4.65e-20
C7852 a2 a_4847_1653# 1.92e-21
C7853 a_219_1929# a_409_3543# 9.68e-21
C7854 a_5284_2589# a_4268_2767# 5.43e-19
C7855 a_4839_4943# a_4399_4943# 0.065575f
C7856 a_5192_4943# a_3072_4399# 2.54e-19
C7857 b3 a_1987_2767# 7.99e-19
C7858 a_2325_5713# a_2688_4943# 4.03e-20
C7859 a_1952_1679# a_1775_854# 1.87e-19
C7860 a_995_4399# a_3799_4118# 1.0762f
C7861 DVDD a_3481_3133# 4.94e-19
C7862 a_757_6281# a_1420_5487# 1.24e-19
C7863 a_2375_4399# a_5587_2767# 3.47e-21
C7864 a_3537_1367# a_5177_1929# 2.04e-19
C7865 a_3517_5487# a_2235_5608# 0.004712f
C7866 a_6219_5309# a_6572_5309# 2.18e-19
C7867 P9 a_1039_1942# 1.42e-19
C7868 a2 a_5653_5095# 5.4e-20
C7869 a_3537_6807# a_4252_6031# 0.00819f
C7870 a_2467_2223# a_1865_749# 7.92e-20
C7871 a_984_6183# a_947_4520# 2.71e-19
C7872 a_757_6281# a5 0.143135f
C7873 P5 a_4399_4943# 9.23e-21
C7874 a_1775_854# a_1865_4013# 0.056505f
C7875 b1 a_5045_6397# 1.46e-20
C7876 a_2045_2223# a_3072_3311# 2.12e-20
C7877 a_2467_2223# a_1823_3855# 0.034184f
C7878 DVDD a_5863_5309# 0.164606f
C7879 a_995_4399# a_1823_3855# 0.035338f
C7880 a_975_3677# a_317_5095# 6.08e-21
C7881 a_1037_4625# a_3072_3311# 0.001501f
C7882 a_3537_1367# a_3847_3855# 0.007085f
C7883 b4 a_4621_6031# 2.05e-19
C7884 a_3523_3030# a_4011_2767# 0.005557f
C7885 a_5188_2223# a_5503_2767# 0.537228f
C7886 a_4544_3855# a_4712_4221# 0.007668f
C7887 a_3983_4520# a_3164_2223# 4.19e-21
C7888 a_2375_4399# a_5503_2767# 2.32e-19
C7889 a_2980_5487# a_3827_6031# 0.008556f
C7890 a_3387_6031# a_3471_6031# 0.097915f
C7891 a_2249_3543# a_2815_4399# 4.06e-19
C7892 a_2467_2223# a_4023_3311# 8.8e-21
C7893 a_1865_4013# a_573_4105# 5.1e-19
C7894 a_2243_1929# a_2244_2767# 0.034299f
C7895 DVDD a_4115_5487# 0.294282f
C7896 a4 a_2467_2223# 0.029598f
C7897 a_1952_1679# a_1039_1942# 2.57e-20
C7898 DVDD a_2285_3311# 5.68e-19
C7899 a3 a_2375_4399# 0.013501f
C7900 a_4073_4625# a_2283_5487# 4.19e-19
C7901 a_3799_4118# a_2235_5608# 1.15e-19
C7902 a_4287_3855# a_4544_3855# 0.023346f
C7903 a_3983_4520# a_3905_5719# 0.001896f
C7904 a_395_2344# a_685_1367# 0.077955f
C7905 a_4533_2449# a_3891_3432# 6.16e-20
C7906 a4 a_995_4399# 4.59e-19
C7907 a3 a_1171_1679# 1.85e-19
C7908 b5 a_2249_4631# 0.077038f
C7909 a_4471_5487# a_4824_5487# 2.18e-19
C7910 b2 a_4931_2223# 2.14e-20
C7911 a_1631_2767# a_1508_1135# 0.00685f
C7912 a3 a_849_4105# 0.321138f
C7913 a_5837_1831# a_4751_1831# 0.002598f
C7914 a_3573_6575# a2 2.8e-22
C7915 a_4667_957# a_5023_957# 0.009846f
C7916 a_1895_6031# a_1329_6183# 0.044609f
C7917 a_2244_2767# a_1823_4943# 5.35e-20
C7918 a_2285_3677# a_1865_4013# 5.79e-20
C7919 a_1823_3855# a_2235_5608# 8.7e-21
C7920 a_1784_1679# a_2045_2223# 0.001266f
C7921 a_1865_4013# a_2283_5487# 4.82e-21
C7922 a_317_743# a_2723_1135# 4.64e-20
C7923 a3 a_3076_5853# 3.29e-19
C7924 a_1823_4943# a_1733_5309# 0.006823f
C7925 a_4533_2449# a_4860_1367# 5.26e-20
C7926 a_3747_6941# b3 6.35e-20
C7927 a_3827_6397# a_3537_6807# 0.023803f
C7928 a_5575_6397# a_5653_5095# 7.95e-21
C7929 a_2325_5713# a_2320_6031# 1.2e-19
C7930 a1 a_849_3017# 8.24e-21
C7931 a_4931_2223# a_4535_854# 0.005696f
C7932 a_2459_4765# a_2815_4765# 0.008475f
C7933 a_5667_4221# a_5821_5101# 5.59e-20
C7934 a_6020_4221# a_5653_5095# 0.004979f
C7935 a_317_2455# a_317_743# 0.002133f
C7936 b2 a_2688_5309# 4.69e-19
C7937 a_3240_4399# a_3072_4399# 0.007701f
C7938 a_5943_3133# a_5653_5095# 3.95e-20
C7939 a_3261_6183# a_3941_5853# 1.53e-20
C7940 P3 a_2283_5487# 1.01e-20
C7941 a_5135_6031# b0 0.022545f
C7942 a_2325_1929# a_1823_3855# 0.008698f
C7943 a_5667_3855# a_4399_4943# 5.95e-21
C7944 a_5311_3855# a_5653_5095# 8.22e-19
C7945 a_6092_3855# a_1823_4943# 1.19e-19
C7946 a_961_1831# a_1328_3677# 0.005587f
C7947 a_5219_6031# a_2235_5608# 1.26e-19
C7948 a_4621_6031# a_4031_5487# 1.14e-19
C7949 a_947_4520# a_883_4943# 2.24e-19
C7950 b1 a_2467_2223# 0.002008f
C7951 a_2723_1501# a_3663_1135# 4.35e-21
C7952 b3 a_355_1653# 0.21727f
C7953 a_1539_6031# a_995_4399# 5.28e-20
C7954 a_1171_2045# a_1039_1942# 0.029489f
C7955 a_1697_743# a_5345_1679# 1.57e-19
C7956 b1 a_995_4399# 0.124079f
C7957 DVDD a_2249_4631# 0.632508f
C7958 a_4751_1831# a_6047_1679# 4.05e-20
C7959 b4 a_4751_1831# 7.24e-21
C7960 b3 a_947_4520# 0.018262f
C7961 a5 a_1987_2767# 0.012701f
C7962 a_995_4399# a_3931_4221# 0.121113f
C7963 a5 a_1251_1501# 3.18e-19
C7964 a_4456_6575# a_3983_5608# 5.8e-20
C7965 a_259_1831# a_961_1831# 0.022207f
C7966 a_3609_4399# a_4471_5487# 4.24e-21
C7967 a_2520_6575# a_4399_4943# 5.14e-19
C7968 a_3983_4520# a_4115_5487# 1.66e-20
C7969 a_1692_4399# a_2327_4520# 0.017745f
C7970 a_3799_4118# a_2341_2455# 3.11e-21
C7971 a5 a_573_2767# 1.93e-19
C7972 a_4931_2589# a_1865_4013# 3.1e-19
C7973 b2 a_2616_5309# 4.98e-19
C7974 a0 a_3241_4943# 1.08e-19
C7975 a_3517_4943# a_2417_4625# 0.00999f
C7976 a_4625_749# a_5873_2045# 0.006823f
C7977 a_1697_743# a_1775_854# 1.32597f
C7978 DVDD a_2723_5853# 8.16e-19
C7979 b4 a_4399_4943# 0.056198f
C7980 a1 a_3983_5608# 0.056977f
C7981 a_1697_743# a_997_1679# 3.41e-20
C7982 a_4709_1929# a_5289_1433# 0.207646f
C7983 a_2341_2455# a_1865_749# 1.88e-20
C7984 a_5173_3631# a_3072_3311# 7.19e-22
C7985 a_2341_2455# a_1823_3855# 0.021319f
C7986 a_1455_6031# a_1823_4943# 4.67e-21
C7987 a_4839_4943# a_4351_5206# 0.005557f
C7988 a_4575_2589# a4 0.002952f
C7989 a_3537_1367# a_443_591# 2.98e-19
C7990 a0 a_443_4943# 0.024251f
C7991 a1 a_1860_4399# -4.32e-35
C7992 b1 a_2235_5608# 0.175163f
C7993 a_3164_2223# a_2249_3543# 2.11e-20
C7994 a_4625_749# a_6412_4007# 0.106501f
C7995 a_763_1256# a_2244_2767# 1.09e-20
C7996 a_2459_3677# a_2249_3543# 0.04028f
C7997 a3 a_1125_3855# 5.15e-19
C7998 a_2243_1929# a_485_749# 6.68e-21
C7999 a_553_1679# a_1865_749# 1.69e-20
C8000 a_553_1679# a_1823_3855# 0.266525f
C8001 a_2467_2223# a_3471_1679# 0.017809f
C8002 a_1775_854# a_3297_1679# 7.63e-19
C8003 P10 a_2045_2223# 4.09e-20
C8004 a_3261_6183# a_2520_6575# 3.98e-19
C8005 a_1865_749# a_2980_1135# 0.742596f
C8006 a_3847_3855# a_5075_1148# 6.88e-21
C8007 a_4023_3311# a_2341_2455# 1.36e-20
C8008 a_5943_2767# a_1823_4943# 1.49e-20
C8009 a_1865_4013# a_5923_1135# 7.25e-21
C8010 a4 a_2341_2455# 0.309335f
C8011 a_2263_591# a_2616_591# 2.18e-19
C8012 DVDD a_1435_4399# 0.1561f
C8013 a_2325_5713# a_984_6183# 2.23e-19
C8014 a_3537_1367# a_4180_1679# 0.005765f
C8015 a_961_1831# a_1400_3311# 0.007765f
C8016 a_4751_1831# a_3571_2767# 7.27e-19
C8017 a_1697_743# a_1039_1942# 5.66e-19
C8018 a_2243_1929# a_1125_3017# 1.01e-19
C8019 a_5188_2223# a_5923_2223# 0.170181f
C8020 a_4115_4399# a_1692_4399# 0.004277f
C8021 a_501_5719# a_2157_5719# 0.00724f
C8022 a_3261_6183# b4 0.013655f
C8023 a_3072_3311# a_1775_4118# 1.85e-20
C8024 a4 a_553_1679# 5.19e-19
C8025 a_2375_4399# a_5923_2223# 1.09e-21
C8026 a_3847_3855# a_1508_1135# 1.22e-19
C8027 a_2375_4399# a_3609_4399# 0.048438f
C8028 a_2249_4631# a_3983_4520# 0.227247f
C8029 a1 a_1329_6183# 0.001844f
C8030 a_2263_4943# a_1775_4118# 2.75e-19
C8031 P7 DGND 0.223044f
C8032 P10 DGND 0.15318f
C8033 P9 DGND 0.215405f
C8034 P8 DGND 0.132264f
C8035 P11 DGND 0.180998f
C8036 P6 DGND 0.143985f
C8037 P0 DGND 0.154924f
C8038 a4 DGND 2.65499f
C8039 b5 DGND 3.537102f
C8040 P5 DGND 0.218397f
C8041 P1 DGND 0.215957f
C8042 b3 DGND 3.64675f
C8043 P4 DGND 0.140017f
C8044 P2 DGND 0.118521f
C8045 b4 DGND 1.663533f
C8046 b2 DGND 2.327063f
C8047 a5 DGND 3.74559f
C8048 a1 DGND 2.0183f
C8049 P3 DGND 0.219179f
C8050 a3 DGND 2.88922f
C8051 a2 DGND 1.30203f
C8052 b0 DGND 3.848333f
C8053 a0 DGND 1.58467f
C8054 b1 DGND 2.217174f
C8055 DVDD DGND 84.3404f
C8056 a_5448_591# DGND 0.001434f
C8057 a_5376_591# DGND 2.82e-19
C8058 a_5023_591# DGND 0.151649f
C8059 a_4667_591# DGND 0.146907f
C8060 a_4493_591# DGND 0.00192f
C8061 a_2688_591# DGND 0.001587f
C8062 a_2616_591# DGND 8.45e-19
C8063 a_2263_591# DGND 0.163077f
C8064 a_1907_591# DGND 0.15789f
C8065 a_1733_591# DGND 0.002135f
C8066 a_1308_591# DGND 0.001879f
C8067 a_1236_591# DGND 8.34e-19
C8068 a_883_591# DGND 0.16296f
C8069 a_527_591# DGND 0.15783f
C8070 a_353_591# DGND 0.002125f
C8071 a_5023_957# DGND 0.004836f
C8072 a_4667_957# DGND 0.003447f
C8073 a_2263_957# DGND 0.004861f
C8074 a_1907_957# DGND 0.003503f
C8075 a_1733_957# DGND 9.78e-21
C8076 a_883_957# DGND 0.004839f
C8077 a_527_957# DGND 0.003447f
C8078 a_1865_749# DGND 0.729312f
C8079 a_485_749# DGND 0.973981f
C8080 a_395_854# DGND 1.4022f
C8081 a_317_743# DGND 1.59148f
C8082 a_6173_1135# DGND 0.001372f
C8083 a_5319_1174# DGND 2.7e-19
C8084 a_6173_1455# DGND 0.004243f
C8085 a_4103_1135# DGND 0.004937f
C8086 a_3747_1135# DGND 0.003681f
C8087 a_2723_1135# DGND 0.004836f
C8088 a_2367_1135# DGND 0.003574f
C8089 a_2193_1135# DGND 4.95e-21
C8090 a_1676_1135# DGND 2.39e-20
C8091 a_1604_1135# DGND 2.37e-20
C8092 a_1251_1135# DGND 0.005208f
C8093 a_895_1135# DGND 0.00346f
C8094 a_5223_1501# DGND 0.002898f
C8095 a_5002_1501# DGND 0.003279f
C8096 a_4528_1501# DGND 0.001538f
C8097 a_4456_1501# DGND 8.34e-19
C8098 a_4103_1501# DGND 0.163359f
C8099 a_3747_1501# DGND 0.160232f
C8100 a_3573_1501# DGND 0.002421f
C8101 a_3148_1501# DGND 0.002254f
C8102 a_3076_1501# DGND 0.001125f
C8103 a_2723_1501# DGND 0.163559f
C8104 a_2367_1501# DGND 0.158018f
C8105 a_2193_1501# DGND 0.002194f
C8106 a_1676_1501# DGND 0.001587f
C8107 a_1604_1501# DGND 9.11e-19
C8108 a_1251_1501# DGND 0.163575f
C8109 a_895_1501# DGND 0.157844f
C8110 a_721_1501# DGND 0.002125f
C8111 a_5923_1135# DGND 0.323215f
C8112 a_2980_1135# DGND 1.92898f
C8113 a_5289_1433# DGND 0.294279f
C8114 a_5075_1148# DGND 1.40918f
C8115 a_443_591# DGND 4.25687f
C8116 a_4860_1367# DGND 0.267034f
C8117 a_3663_1135# DGND 1.53628f
C8118 a_6828_1679# DGND 0.001424f
C8119 a_6756_1679# DGND 2.82e-19
C8120 a_6403_1679# DGND 0.151638f
C8121 a_6047_1679# DGND 0.14664f
C8122 a_5873_1679# DGND 0.002056f
C8123 a_5345_1679# DGND 0.003975f
C8124 a_4877_1679# DGND 0.003814f
C8125 a_4793_1679# DGND 0.001787f
C8126 a_4709_1679# DGND 0.002717f
C8127 a_4252_1679# DGND 0.001937f
C8128 a_4180_1679# DGND 2.82e-19
C8129 a_3827_1679# DGND 0.197626f
C8130 a_3471_1679# DGND 0.184566f
C8131 a_3297_1679# DGND 0.002151f
C8132 a_6403_2045# DGND 0.004836f
C8133 a_6047_2045# DGND 0.003447f
C8134 a_5345_1929# DGND 0.001372f
C8135 a_4709_1929# DGND 0.683512f
C8136 a_2493_1679# DGND 0.004357f
C8137 a_1952_1679# DGND 0.001609f
C8138 a_1880_1679# DGND 8.88e-19
C8139 a_1527_1679# DGND 0.209225f
C8140 a_1171_1679# DGND 0.191176f
C8141 a_997_1679# DGND 0.002298f
C8142 a_4252_2045# DGND 6.28e-20
C8143 a_4180_2045# DGND 1.59e-19
C8144 a_3537_1367# DGND 1.00956f
C8145 a_3827_2045# DGND 0.090619f
C8146 a_3471_2045# DGND 0.099519f
C8147 a_3297_2045# DGND 6.33e-20
C8148 a_2493_1929# DGND 0.004238f
C8149 a_2325_1929# DGND 5.12e-19
C8150 a_469_1679# DGND 0.005268f
C8151 a_1952_2045# DGND 2.15e-19
C8152 a_1880_2045# DGND 3.88e-20
C8153 a_1784_1679# DGND 1.05188f
C8154 a_1527_2045# DGND 0.089637f
C8155 a_1171_2045# DGND 0.093189f
C8156 a_469_1929# DGND 0.002505f
C8157 a_301_1929# DGND 0.001767f
C8158 a_4625_749# DGND 2.03423f
C8159 a_5095_1929# DGND 0.30902f
C8160 a_1697_743# DGND 1.6573f
C8161 a_4847_1653# DGND 0.40033f
C8162 a_4751_1831# DGND 0.661848f
C8163 a_2235_1256# DGND 1.19505f
C8164 a_2243_1929# DGND 0.31764f
C8165 a_553_1679# DGND 0.524477f
C8166 a_763_1256# DGND 1.34711f
C8167 a_219_1929# DGND 0.39502f
C8168 a_259_1831# DGND 1.00555f
C8169 a_6173_2223# DGND 0.001372f
C8170 a_4931_2223# DGND 0.004836f
C8171 a_4575_2223# DGND 0.003697f
C8172 a_4401_2223# DGND 3.25e-20
C8173 a_3332_2223# DGND 2.09e-19
C8174 a_3260_2223# DGND 1.63e-19
C8175 a_2907_2223# DGND 0.006384f
C8176 a_2551_2223# DGND 0.006408f
C8177 a_2377_2223# DGND 2.61e-20
C8178 a_4457_743# DGND 0.822943f
C8179 a_4943_1653# DGND 0.311458f
C8180 a_6173_2543# DGND 0.005523f
C8181 a_1308_2223# DGND 6.06e-20
C8182 a_1236_2223# DGND 2.81e-19
C8183 a_883_2223# DGND 0.086003f
C8184 a_527_2223# DGND 0.092717f
C8185 a_5356_2589# DGND 0.001587f
C8186 a_5284_2589# DGND 8.65e-19
C8187 a_4931_2589# DGND 0.163293f
C8188 a_4575_2589# DGND 0.158588f
C8189 a_4401_2589# DGND 0.002407f
C8190 a_3332_2589# DGND 0.004084f
C8191 a_3260_2589# DGND 0.001787f
C8192 a_2907_2589# DGND 0.194706f
C8193 a_2551_2589# DGND 0.185961f
C8194 a_2377_2589# DGND 0.002947f
C8195 a_2045_2543# DGND 0.002422f
C8196 a_1769_2543# DGND 0.001895f
C8197 a_1308_2589# DGND 0.001703f
C8198 a_1236_2589# DGND 4.55e-19
C8199 a_685_1367# DGND 1.03864f
C8200 a_883_2589# DGND 0.198533f
C8201 a_527_2589# DGND 0.191851f
C8202 a_353_2589# DGND 0.002125f
C8203 a_5923_2223# DGND 0.338561f
C8204 a_5188_2223# DGND 1.02085f
C8205 a_1775_854# DGND 2.90898f
C8206 a_2467_2223# DGND 2.18084f
C8207 a_2045_2223# DGND 0.742684f
C8208 a_355_1653# DGND 0.980539f
C8209 a_317_2455# DGND 1.45284f
C8210 a_6368_2767# DGND 0.001511f
C8211 a_6296_2767# DGND 8.34e-19
C8212 a_5943_2767# DGND 0.16296f
C8213 a_5587_2767# DGND 0.15783f
C8214 a_5413_2767# DGND 0.002125f
C8215 a_4535_854# DGND 0.827503f
C8216 a_5081_2767# DGND 0.00198f
C8217 a_4805_2767# DGND 0.002003f
C8218 a_4436_2767# DGND 0.001536f
C8219 a_4364_2767# DGND 8.34e-19
C8220 a_4011_2767# DGND 0.163413f
C8221 a_3655_2767# DGND 0.160036f
C8222 a_3481_2767# DGND 0.003018f
C8223 a_5837_1831# DGND 0.947407f
C8224 a_5943_3133# DGND 0.004836f
C8225 a_5587_3133# DGND 0.003447f
C8226 a_4533_2449# DGND 0.650398f
C8227 a_2781_2767# DGND 0.002082f
C8228 a_2412_2767# DGND 0.001679f
C8229 a_2340_2767# DGND 9.67e-19
C8230 a_1987_2767# DGND 0.165404f
C8231 a_1631_2767# DGND 0.157819f
C8232 a_1457_2767# DGND 0.002125f
C8233 a_4268_2767# DGND 1.02809f
C8234 a_4011_3133# DGND 0.005067f
C8235 a_3655_3133# DGND 0.008516f
C8236 a_3481_3133# DGND 1.04e-19
C8237 a_1125_2767# DGND 0.00198f
C8238 a_849_2767# DGND 0.001738f
C8239 a_573_2767# DGND 0.001738f
C8240 a_297_2767# DGND 0.002003f
C8241 a_2244_2767# DGND 1.54366f
C8242 a_1987_3133# DGND 0.004968f
C8243 a_1631_3133# DGND 0.003447f
C8244 a_1125_3017# DGND 0.912348f
C8245 a_5503_2767# DGND 1.2583f
C8246 a_3571_2767# DGND 1.62934f
C8247 a_3164_2223# DGND 1.33937f
C8248 a_1039_1942# DGND 1.79261f
C8249 a_849_3017# DGND 0.698833f
C8250 a_1421_2919# DGND 0.913617f
C8251 a_4379_3311# DGND 0.004836f
C8252 a_4023_3311# DGND 0.004095f
C8253 a_3849_3311# DGND 2.58e-20
C8254 a_3240_3311# DGND 1.64e-19
C8255 a_3168_3311# DGND 1.51e-19
C8256 a_2815_3311# DGND 0.004836f
C8257 a_2459_3311# DGND 0.003447f
C8258 a_5545_2925# DGND 0.537317f
C8259 a_2341_2455# DGND 1.48953f
C8260 a_5173_3631# DGND 0.001893f
C8261 a_975_3311# DGND 0.004844f
C8262 a_619_3311# DGND 0.003447f
C8263 a_4804_3677# DGND 0.001691f
C8264 a_4732_3677# DGND 8.34e-19
C8265 a_4379_3677# DGND 0.162972f
C8266 a_4023_3677# DGND 0.152642f
C8267 a_3849_3677# DGND 0.002032f
C8268 a_3240_3677# DGND 0.001664f
C8269 a_3168_3677# DGND 0.001095f
C8270 a_2815_3677# DGND 0.163205f
C8271 a_2459_3677# DGND 0.15783f
C8272 a_2285_3677# DGND 0.002125f
C8273 a_1769_3631# DGND 0.001642f
C8274 a_1400_3677# DGND 0.00198f
C8275 a_1328_3677# DGND 8.34e-19
C8276 a_961_1831# DGND 1.52746f
C8277 a_975_3677# DGND 0.162963f
C8278 a_619_3677# DGND 0.15783f
C8279 a_445_3677# DGND 0.002125f
C8280 a_4636_3311# DGND 0.614024f
C8281 a_3523_3030# DGND 1.06034f
C8282 a_3813_3543# DGND 0.72667f
C8283 a_2375_3311# DGND 1.22079f
C8284 a_2327_3432# DGND 0.647347f
C8285 a_395_2344# DGND 1.8531f
C8286 a_297_3017# DGND 0.694104f
C8287 a_409_3543# DGND 0.775254f
C8288 a_6737_3855# DGND 0.001601f
C8289 a_6092_3855# DGND 0.001666f
C8290 a_6020_3855# DGND 2.82e-19
C8291 a_5667_3855# DGND 0.157642f
C8292 a_5311_3855# DGND 0.15783f
C8293 a_5137_3855# DGND 0.002125f
C8294 a_4712_3855# DGND 0.001434f
C8295 a_4640_3855# DGND 8.34e-19
C8296 a_4287_3855# DGND 0.151651f
C8297 a_3931_3855# DGND 0.14664f
C8298 a_3757_3855# DGND 0.001883f
C8299 a_3891_3432# DGND 1.04602f
C8300 a_3241_3855# DGND 0.001653f
C8301 a_2688_3855# DGND 0.001547f
C8302 a_2616_3855# DGND 8.34e-19
C8303 a_2263_3855# DGND 0.151651f
C8304 a_1907_3855# DGND 0.146693f
C8305 a_1733_3855# DGND 0.001883f
C8306 a_5667_4221# DGND 0.004836f
C8307 a_5311_4221# DGND 0.003447f
C8308 a_4544_3855# DGND 1.04707f
C8309 a_4287_4221# DGND 0.004836f
C8310 a_3931_4221# DGND 0.004868f
C8311 a_3757_4221# DGND 3.05e-20
C8312 a_2249_3543# DGND 1.08298f
C8313 a_1401_3855# DGND 0.001716f
C8314 a_1125_3855# DGND 0.001738f
C8315 a_849_3855# DGND 0.001944f
C8316 a_573_3855# DGND 0.002003f
C8317 a_297_3855# DGND 0.001709f
C8318 a_2520_3855# DGND 0.869281f
C8319 a_2263_4221# DGND 0.004836f
C8320 a_1907_4221# DGND 0.003447f
C8321 a_849_4105# DGND 1.46884f
C8322 a_573_4105# DGND 0.744904f
C8323 a_297_4105# DGND 1.04085f
C8324 a_6412_4007# DGND 0.627321f
C8325 a_5227_3855# DGND 1.07179f
C8326 a_3847_3855# DGND 1.02724f
C8327 a_3072_3311# DGND 1.49783f
C8328 a_1823_3855# DGND 0.741613f
C8329 a_1865_4013# DGND 1.8338f
C8330 a_1775_4118# DGND 1.29414f
C8331 a_1508_1135# DGND 1.19653f
C8332 a_4471_4399# DGND 0.004836f
C8333 a_4115_4399# DGND 0.003654f
C8334 a_3941_4399# DGND 2.09e-20
C8335 a_6277_4719# DGND 0.00164f
C8336 a_5541_4719# DGND 0.001711f
C8337 a_5265_4719# DGND 0.001709f
C8338 a_3240_4399# DGND 1.08e-19
C8339 a_3168_4399# DGND 7.99e-20
C8340 a_2815_4399# DGND 0.004836f
C8341 a_2459_4399# DGND 0.003447f
C8342 a_1435_4399# DGND 0.004836f
C8343 a_1079_4399# DGND 0.003448f
C8344 a_4896_4765# DGND 0.001536f
C8345 a_4824_4765# DGND 2.82e-19
C8346 a_4471_4765# DGND 0.15129f
C8347 a_4115_4765# DGND 0.15783f
C8348 a_3941_4765# DGND 0.002125f
C8349 a_3609_4719# DGND 0.001922f
C8350 a_3240_4765# DGND 0.002386f
C8351 a_3168_4765# DGND 3.34e-19
C8352 a_2815_4765# DGND 0.151638f
C8353 a_2459_4765# DGND 0.14664f
C8354 a_2285_4765# DGND 0.001883f
C8355 a_1860_4765# DGND 0.001434f
C8356 a_1788_4765# DGND 2.82e-19
C8357 a_1692_4399# DGND 0.849534f
C8358 a_1435_4765# DGND 0.151638f
C8359 a_1079_4765# DGND 0.146642f
C8360 a_905_4765# DGND 0.001877f
C8361 a_573_4719# DGND 0.001677f
C8362 a_4728_4399# DGND 0.383743f
C8363 a_3799_4118# DGND 0.915355f
C8364 a_4073_4625# DGND 0.534983f
C8365 a_3983_4520# DGND 1.1593f
C8366 a_3609_4399# DGND 0.700677f
C8367 a_2375_4399# DGND 0.866856f
C8368 a_2249_4631# DGND 1.20624f
C8369 a_995_4399# DGND 0.747229f
C8370 a_1037_4625# DGND 0.696241f
C8371 a_947_4520# DGND 0.604724f
C8372 a_248_4631# DGND 0.434811f
C8373 a_6644_4943# DGND 0.001907f
C8374 a_6572_4943# DGND 8.75e-19
C8375 a_6219_4943# DGND 0.163011f
C8376 a_5863_4943# DGND 0.157883f
C8377 a_5689_4943# DGND 0.002125f
C8378 a_5264_4943# DGND 0.001434f
C8379 a_5192_4943# DGND 2.82e-19
C8380 a_4839_4943# DGND 0.151638f
C8381 a_4483_4943# DGND 0.14664f
C8382 a_4309_4943# DGND 0.002125f
C8383 a_3977_4943# DGND 0.00198f
C8384 a_3517_4943# DGND 0.001757f
C8385 a_3241_4943# DGND 0.001855f
C8386 a_2688_4943# DGND 0.001589f
C8387 a_2616_4943# DGND 2.82e-19
C8388 a_2263_4943# DGND 0.151638f
C8389 a_1907_4943# DGND 0.149195f
C8390 a_1733_4943# DGND 0.002125f
C8391 a_1308_4943# DGND 0.001879f
C8392 a_1236_4943# DGND 8.34e-19
C8393 a_883_4943# DGND 0.16296f
C8394 a_527_4943# DGND 0.15783f
C8395 a_353_4943# DGND 0.002125f
C8396 a_6644_5309# DGND 5.75e-21
C8397 a_6572_5309# DGND 2.95e-20
C8398 a_6219_5309# DGND 0.005218f
C8399 a_5863_5309# DGND 0.003577f
C8400 a_4839_5309# DGND 0.004836f
C8401 a_4483_5309# DGND 0.003447f
C8402 a_2417_4625# DGND 0.878041f
C8403 a_2327_4520# DGND 0.9772f
C8404 a_2263_5309# DGND 0.004836f
C8405 a_1907_5309# DGND 0.003447f
C8406 a_883_5309# DGND 0.004836f
C8407 a_527_5309# DGND 0.003765f
C8408 a_5779_4943# DGND 1.30837f
C8409 a_5821_5101# DGND 0.94258f
C8410 a_5653_5095# DGND 1.12093f
C8411 a_4399_4943# DGND 1.40179f
C8412 a_3072_4399# DGND 0.92677f
C8413 a_1823_4943# DGND 1.24546f
C8414 a_317_5095# DGND 0.865669f
C8415 a_4471_5487# DGND 0.004836f
C8416 a_4115_5487# DGND 0.003447f
C8417 a_5265_5807# DGND 0.002027f
C8418 a_2723_5487# DGND 0.004836f
C8419 a_2367_5487# DGND 0.003574f
C8420 a_4896_5853# DGND 0.001791f
C8421 a_4824_5853# DGND 9.05e-19
C8422 a_4351_5206# DGND 0.772901f
C8423 a_4471_5853# DGND 0.164361f
C8424 a_4115_5853# DGND 0.159197f
C8425 a_3941_5853# DGND 0.002125f
C8426 a_3517_5807# DGND 0.001767f
C8427 a_1067_5487# DGND 0.115967f
C8428 a_711_5487# DGND 0.107767f
C8429 a_3148_5853# DGND 0.00198f
C8430 a_3076_5853# DGND 8.34e-19
C8431 a_2723_5853# DGND 0.16296f
C8432 a_2367_5853# DGND 0.152492f
C8433 a_2193_5853# DGND 0.001883f
C8434 a_1861_5807# DGND 0.001922f
C8435 a_1492_5853# DGND 0.0017f
C8436 a_1420_5853# DGND 2.85e-19
C8437 a_1067_5853# DGND 0.196708f
C8438 a_711_5853# DGND 0.217813f
C8439 a_537_5853# DGND 0.002792f
C8440 a_6412_5719# DGND 0.610327f
C8441 a_4031_5487# DGND 1.72405f
C8442 a_3905_5719# DGND 0.717179f
C8443 a_2283_5487# DGND 1.04672f
C8444 a_2235_5608# DGND 0.843852f
C8445 a_443_4943# DGND 2.09907f
C8446 a_6000_6031# DGND 0.001549f
C8447 a_5928_6031# DGND 6.78e-19
C8448 a_5575_6031# DGND 0.157398f
C8449 a_5219_6031# DGND 0.148258f
C8450 a_5045_6031# DGND 0.00199f
C8451 a_4621_6031# DGND 0.001752f
C8452 a_4252_6031# DGND 0.001753f
C8453 a_4180_6031# DGND 6.74e-19
C8454 a_3827_6031# DGND 0.151638f
C8455 a_3471_6031# DGND 0.148518f
C8456 a_3297_6031# DGND 0.002495f
C8457 a_6000_6397# DGND 7.74e-20
C8458 a_5928_6397# DGND 1.15e-19
C8459 a_5575_6397# DGND 0.007991f
C8460 a_5219_6397# DGND 0.006479f
C8461 a_5045_6397# DGND 3.39e-20
C8462 a_3983_5608# DGND 0.85884f
C8463 a_2689_6031# DGND 0.001646f
C8464 a_2320_6031# DGND 0.001691f
C8465 a_2248_6031# DGND 2.82e-19
C8466 a_1895_6031# DGND 0.151667f
C8467 a_1539_6031# DGND 0.14664f
C8468 a_1365_6031# DGND 0.001883f
C8469 a_4252_6397# DGND 4.75e-20
C8470 a_4180_6397# DGND 1.15e-19
C8471 a_3827_6397# DGND 0.007505f
C8472 a_3471_6397# DGND 0.008907f
C8473 a_3297_6397# DGND 8.53e-20
C8474 a_2325_5713# DGND 0.697343f
C8475 a_757_6031# DGND 0.001677f
C8476 a_481_6031# DGND 0.001944f
C8477 a_501_5719# DGND 1.96984f
C8478 a_1895_6397# DGND 0.004978f
C8479 a_1539_6397# DGND 0.003447f
C8480 a_757_6281# DGND 1.04446f
C8481 a_5135_6031# DGND 0.793057f
C8482 a_5009_6183# DGND 0.837962f
C8483 a_3387_6031# DGND 1.40554f
C8484 a_2980_5487# DGND 0.972762f
C8485 a_1455_6031# DGND 0.817132f
C8486 a_1497_6189# DGND 0.622511f
C8487 a_481_6281# DGND 0.678962f
C8488 a_984_6183# DGND 0.805009f
C8489 a_4528_6575# DGND 1.55e-19
C8490 a_4456_6575# DGND 1.41e-19
C8491 a_4103_6575# DGND 0.009057f
C8492 a_3747_6575# DGND 0.009766f
C8493 a_3573_6575# DGND 6.39e-20
C8494 a_3261_6183# DGND 0.830835f
C8495 a_2688_6575# DGND 1.69e-19
C8496 a_2616_6575# DGND 3.83e-19
C8497 a_2263_6575# DGND 0.087681f
C8498 a_1907_6575# DGND 0.093201f
C8499 a_4528_6941# DGND 0.001511f
C8500 a_4456_6941# DGND 2.82e-19
C8501 a_4103_6941# DGND 0.151638f
C8502 a_3747_6941# DGND 0.14664f
C8503 a_3573_6941# DGND 0.001983f
C8504 a_2157_5719# DGND 0.87064f
C8505 a_3241_6895# DGND 0.001753f
C8506 a_2688_6941# DGND 0.001589f
C8507 a_2616_6941# DGND 4.02e-19
C8508 a_2520_6575# DGND 3.45219f
C8509 a_2263_6941# DGND 0.196976f
C8510 a_1907_6941# DGND 0.179892f
C8511 a_1733_6941# DGND 0.001883f
C8512 a_1329_6183# DGND 0.683037f
C8513 a_1401_6895# DGND 0.001716f
C8514 a_1125_6895# DGND 0.001944f
C8515 a_3517_5487# DGND 1.64888f
C8516 a_627_5487# DGND 2.47423f
C8517 a_3537_6807# DGND 0.862715f
C8518 a_1823_6575# DGND 0.976305f
C8519 a_1775_6696# DGND 2.05413f
C8520 a_1697_5095.n0 DGND 1.13748f
C8521 a_1697_5095.t0 DGND 0.056134f
C8522 a_1697_5095.t5 DGND 0.021899f
C8523 a_1697_5095.t8 DGND 0.013792f
C8524 a_1697_5095.n1 DGND 0.045013f
C8525 a_1697_5095.t2 DGND 0.021215f
C8526 a_1697_5095.t3 DGND 0.014454f
C8527 a_1697_5095.n2 DGND 0.044533f
C8528 a_1697_5095.t6 DGND 0.020617f
C8529 a_1697_5095.t9 DGND 0.015036f
C8530 a_1697_5095.n3 DGND 0.045139f
C8531 a_1697_5095.n4 DGND 0.136938f
C8532 a_1697_5095.t4 DGND 0.02327f
C8533 a_1697_5095.t7 DGND 0.012484f
C8534 a_1697_5095.n5 DGND 0.044638f
C8535 a_1697_5095.n6 DGND 0.492409f
C8536 a_1697_5095.t1 DGND 0.054946f
C8537 b0.t1 DGND 0.018916f
C8538 b0.t10 DGND 0.011805f
C8539 b0.n0 DGND 0.03723f
C8540 b0.t7 DGND 0.011805f
C8541 b0.t2 DGND 0.018916f
C8542 b0.n1 DGND 0.03723f
C8543 b0.t0 DGND 0.011805f
C8544 b0.t6 DGND 0.018916f
C8545 b0.n2 DGND 0.03723f
C8546 b0.n3 DGND 1.35428f
C8547 b0.t3 DGND 0.011805f
C8548 b0.t8 DGND 0.018916f
C8549 b0.n4 DGND 0.03723f
C8550 b0.n5 DGND 0.1648f
C8551 b0.t4 DGND 0.018916f
C8552 b0.t9 DGND 0.011805f
C8553 b0.n6 DGND 0.03723f
C8554 b0.n7 DGND 0.195444f
C8555 b0.t11 DGND 0.011805f
C8556 b0.t5 DGND 0.018916f
C8557 b0.n8 DGND 0.03723f
C8558 b0.n9 DGND 0.335144f
C8559 a_395_5206.n0 DGND 0.875281f
C8560 a_395_5206.t2 DGND 0.026656f
C8561 a_395_5206.t1 DGND 0.127014f
C8562 a_395_5206.t5 DGND 0.021258f
C8563 a_395_5206.t7 DGND 0.039625f
C8564 a_395_5206.n1 DGND 0.077685f
C8565 a_395_5206.t6 DGND 0.020298f
C8566 a_395_5206.t8 DGND 0.040648f
C8567 a_395_5206.n2 DGND 0.078983f
C8568 a_395_5206.t9 DGND 0.035209f
C8569 a_395_5206.t3 DGND 0.014611f
C8570 a_395_5206.n3 DGND 0.068405f
C8571 a_395_5206.t10 DGND 0.040457f
C8572 a_395_5206.t4 DGND 0.015032f
C8573 a_395_5206.n4 DGND 0.072118f
C8574 a_395_5206.n5 DGND 0.058548f
C8575 a_395_5206.n6 DGND 0.407989f
C8576 a_395_5206.n7 DGND 0.053524f
C8577 a_395_5206.t0 DGND 0.026656f
C8578 b4.t2 DGND 0.020956f
C8579 b4.t8 DGND 0.013079f
C8580 b4.n0 DGND 0.041246f
C8581 b4.t9 DGND 0.020956f
C8582 b4.t3 DGND 0.013079f
C8583 b4.n1 DGND 0.041246f
C8584 b4.t5 DGND 0.013079f
C8585 b4.t1 DGND 0.020956f
C8586 b4.n2 DGND 0.041246f
C8587 b4.t7 DGND 0.020956f
C8588 b4.t10 DGND 0.013079f
C8589 b4.n3 DGND 0.041246f
C8590 b4.n4 DGND 0.401131f
C8591 b4.t6 DGND 0.020956f
C8592 b4.t0 DGND 0.013079f
C8593 b4.n5 DGND 0.041246f
C8594 b4.n6 DGND 0.858763f
C8595 b4.t11 DGND 0.020956f
C8596 b4.t4 DGND 0.013079f
C8597 b4.n7 DGND 0.041246f
C8598 b4.n8 DGND 0.412269f
C8599 b4.n9 DGND 0.090136f
C8600 a_2520_591.t3 DGND 0.011414f
C8601 a_2520_591.t2 DGND 0.011414f
C8602 a_2520_591.t0 DGND 0.016486f
C8603 a_2520_591.n0 DGND 0.083846f
C8604 a_2520_591.t4 DGND 0.028115f
C8605 a_2520_591.t5 DGND 0.045017f
C8606 a_2520_591.n1 DGND 0.33517f
C8607 a_2520_591.n2 DGND 2.01623f
C8608 a_2520_591.n3 DGND 0.035823f
C8609 a_2520_591.t1 DGND 0.016486f
C8610 b5.t8 DGND 0.021146f
C8611 b5.t2 DGND 0.013197f
C8612 b5.n0 DGND 0.041619f
C8613 b5.t6 DGND 0.013197f
C8614 b5.t1 DGND 0.021146f
C8615 b5.n1 DGND 0.041619f
C8616 b5.t10 DGND 0.021146f
C8617 b5.t5 DGND 0.013197f
C8618 b5.n2 DGND 0.041619f
C8619 b5.t3 DGND 0.021146f
C8620 b5.t9 DGND 0.013197f
C8621 b5.n3 DGND 0.041619f
C8622 b5.n4 DGND 0.402703f
C8623 b5.n5 DGND 1.04927f
C8624 b5.t7 DGND 0.021146f
C8625 b5.t0 DGND 0.013197f
C8626 b5.n6 DGND 0.041619f
C8627 b5.n7 DGND 0.528647f
C8628 b5.t4 DGND 0.021146f
C8629 b5.t11 DGND 0.013197f
C8630 b5.n8 DGND 0.041619f
C8631 b5.n9 DGND 0.190238f
C8632 b2.t7 DGND 0.019699f
C8633 b2.t0 DGND 0.012294f
C8634 b2.n0 DGND 0.038771f
C8635 b2.t10 DGND 0.012294f
C8636 b2.t3 DGND 0.019699f
C8637 b2.n1 DGND 0.038771f
C8638 b2.t1 DGND 0.012294f
C8639 b2.t5 DGND 0.019699f
C8640 b2.n2 DGND 0.038771f
C8641 b2.t4 DGND 0.019699f
C8642 b2.t11 DGND 0.012294f
C8643 b2.n3 DGND 0.038771f
C8644 b2.n4 DGND 1.04251f
C8645 b2.t9 DGND 0.012294f
C8646 b2.t2 DGND 0.019699f
C8647 b2.n5 DGND 0.038771f
C8648 b2.n6 DGND 0.248821f
C8649 b2.n7 DGND 0.268376f
C8650 b2.n8 DGND 0.33045f
C8651 b2.t6 DGND 0.019699f
C8652 b2.t8 DGND 0.012294f
C8653 b2.n9 DGND 0.038759f
C8654 b2.n10 DGND 0.1007f
C8655 b1.t0 DGND 0.016992f
C8656 b1.t6 DGND 0.010605f
C8657 b1.n0 DGND 0.033444f
C8658 b1.t11 DGND 0.010605f
C8659 b1.t4 DGND 0.016992f
C8660 b1.n1 DGND 0.033444f
C8661 b1.t5 DGND 0.016992f
C8662 b1.t10 DGND 0.010605f
C8663 b1.n2 DGND 0.033444f
C8664 b1.n3 DGND 0.274583f
C8665 b1.t2 DGND 0.016992f
C8666 b1.t7 DGND 0.010605f
C8667 b1.n4 DGND 0.033444f
C8668 b1.t8 DGND 0.016992f
C8669 b1.t1 DGND 0.010605f
C8670 b1.n5 DGND 0.033444f
C8671 b1.t3 DGND 0.010605f
C8672 b1.t9 DGND 0.016992f
C8673 b1.n6 DGND 0.033444f
C8674 b1.n7 DGND 0.31483f
C8675 b1.n8 DGND 0.615368f
C8676 b1.n9 DGND 0.180227f
C8677 a_1775_5206.n0 DGND 1.25794f
C8678 a_1775_5206.t7 DGND 0.010747f
C8679 a_1775_5206.t9 DGND 0.020033f
C8680 a_1775_5206.n1 DGND 0.039274f
C8681 a_1775_5206.t5 DGND 0.010262f
C8682 a_1775_5206.t8 DGND 0.02055f
C8683 a_1775_5206.n2 DGND 0.03993f
C8684 a_1775_5206.t2 DGND 0.0178f
C8685 a_1775_5206.t4 DGND 0.007387f
C8686 a_1775_5206.n3 DGND 0.034583f
C8687 a_1775_5206.t3 DGND 0.020453f
C8688 a_1775_5206.t6 DGND 0.0076f
C8689 a_1775_5206.n4 DGND 0.03646f
C8690 a_1775_5206.n5 DGND 0.029599f
C8691 a_1775_5206.t0 DGND 0.026605f
C8692 a_1775_5206.n6 DGND 0.556384f
C8693 a_1775_5206.t1 DGND 0.06439f
C8694 a5.t0 DGND 0.018252f
C8695 a5.t5 DGND 0.011396f
C8696 a5.n0 DGND 0.034742f
C8697 a5.t4 DGND 0.018252f
C8698 a5.t10 DGND 0.011396f
C8699 a5.n1 DGND 0.034742f
C8700 a5.n2 DGND 0.352823f
C8701 a5.t1 DGND 0.011396f
C8702 a5.t6 DGND 0.018252f
C8703 a5.n3 DGND 0.034783f
C8704 a5.n4 DGND 0.025537f
C8705 a5.t8 DGND 0.018252f
C8706 a5.t2 DGND 0.011396f
C8707 a5.n5 DGND 0.034742f
C8708 a5.n6 DGND 0.509569f
C8709 a5.n7 DGND 0.615668f
C8710 a5.t9 DGND 0.018252f
C8711 a5.t3 DGND 0.011396f
C8712 a5.n8 DGND 0.034742f
C8713 a5.n9 DGND 0.743482f
C8714 a5.t7 DGND 0.011396f
C8715 a5.t11 DGND 0.018252f
C8716 a5.n10 DGND 0.034742f
C8717 a_1697_6807.n0 DGND 1.20009f
C8718 a_1697_6807.t2 DGND 0.010365f
C8719 a_1697_6807.t3 DGND 0.010365f
C8720 a_1697_6807.t1 DGND 0.014972f
C8721 a_1697_6807.n1 DGND 0.028128f
C8722 a_1697_6807.t4 DGND 0.021744f
C8723 a_1697_6807.t8 DGND 0.034526f
C8724 a_1697_6807.n2 DGND 0.070967f
C8725 a_1697_6807.t10 DGND 0.022787f
C8726 a_1697_6807.t6 DGND 0.033447f
C8727 a_1697_6807.n3 DGND 0.070209f
C8728 a_1697_6807.t5 DGND 0.023705f
C8729 a_1697_6807.t9 DGND 0.032505f
C8730 a_1697_6807.n4 DGND 0.071165f
C8731 a_1697_6807.t11 DGND 0.019682f
C8732 a_1697_6807.t7 DGND 0.036686f
C8733 a_1697_6807.n5 DGND 0.070375f
C8734 a_1697_6807.n6 DGND 0.90714f
C8735 a_1697_6807.n7 DGND 0.106167f
C8736 a_1697_6807.t0 DGND 0.014972f
C8737 a4.t5 DGND 0.017913f
C8738 a4.t0 DGND 0.011185f
C8739 a4.n0 DGND 0.034098f
C8740 a4.t11 DGND 0.017913f
C8741 a4.t6 DGND 0.011185f
C8742 a4.n1 DGND 0.034098f
C8743 a4.n2 DGND 0.108941f
C8744 a4.t7 DGND 0.017913f
C8745 a4.t1 DGND 0.011185f
C8746 a4.n3 DGND 0.034098f
C8747 a4.n4 DGND 0.341294f
C8748 a4.t2 DGND 0.011185f
C8749 a4.t8 DGND 0.017913f
C8750 a4.n5 DGND 0.034098f
C8751 a4.n6 DGND 0.251749f
C8752 a4.t9 DGND 0.017913f
C8753 a4.t3 DGND 0.011185f
C8754 a4.n7 DGND 0.034098f
C8755 a4.n8 DGND 0.985021f
C8756 a4.t4 DGND 0.011185f
C8757 a4.t10 DGND 0.017913f
C8758 a4.n9 DGND 0.034098f
C8759 DVDD.n0 DGND 0.032405f
C8760 DVDD.n1 DGND 0.077519f
C8761 DVDD.n2 DGND 0.020611f
C8762 DVDD.n3 DGND 0.003654f
C8763 DVDD.t29 DGND 0.004651f
C8764 DVDD.n4 DGND 0.017689f
C8765 DVDD.t326 DGND 0.00237f
C8766 DVDD.n5 DGND 0.004264f
C8767 DVDD.n6 DGND 0.001203f
C8768 DVDD.t320 DGND 4.69e-19
C8769 DVDD.t692 DGND 4.69e-19
C8770 DVDD.n7 DGND 9.72e-19
C8771 DVDD.n8 DGND 0.00369f
C8772 DVDD.n9 DGND 0.003654f
C8773 DVDD.t73 DGND 0.001713f
C8774 DVDD.n10 DGND 4.57e-19
C8775 DVDD.t28 DGND 0.121283f
C8776 DVDD.t325 DGND 0.04753f
C8777 DVDD.t70 DGND 0.019667f
C8778 DVDD.t693 DGND 0.019667f
C8779 DVDD.t26 DGND 0.021658f
C8780 DVDD.t319 DGND 0.020253f
C8781 DVDD.t691 DGND 0.019667f
C8782 DVDD.t72 DGND 0.025287f
C8783 DVDD.n11 DGND 9.7e-19
C8784 DVDD.t470 DGND 4.69e-19
C8785 DVDD.t163 DGND 4.69e-19
C8786 DVDD.n12 DGND 9.6e-19
C8787 DVDD.n13 DGND 0.00257f
C8788 DVDD.n14 DGND 0.003654f
C8789 DVDD.t944 DGND 0.001067f
C8790 DVDD.t789 DGND 0.001477f
C8791 DVDD.n15 DGND 0.006432f
C8792 DVDD.t961 DGND 0.001573f
C8793 DVDD.t819 DGND 9.84e-19
C8794 DVDD.n16 DGND 0.00305f
C8795 DVDD.n17 DGND 0.011169f
C8796 DVDD.t952 DGND 0.00166f
C8797 DVDD.t776 DGND 8.91e-19
C8798 DVDD.n18 DGND 0.003043f
C8799 DVDD.n19 DGND 0.025031f
C8800 DVDD.t468 DGND 0.002359f
C8801 DVDD.n20 DGND 0.002516f
C8802 DVDD.n21 DGND 0.003654f
C8803 DVDD.n22 DGND 6.96e-19
C8804 DVDD.n23 DGND 0.003654f
C8805 DVDD.t146 DGND 0.001713f
C8806 DVDD.n24 DGND 8.44e-19
C8807 DVDD.n25 DGND 0.003654f
C8808 DVDD.t908 DGND 0.001713f
C8809 DVDD.t374 DGND 4.69e-19
C8810 DVDD.t824 DGND 4.69e-19
C8811 DVDD.n26 DGND 9.72e-19
C8812 DVDD.n27 DGND 0.003599f
C8813 DVDD.n28 DGND 0.003654f
C8814 DVDD.t677 DGND 0.00237f
C8815 DVDD.n29 DGND 0.003654f
C8816 DVDD.t395 DGND 0.004456f
C8817 DVDD.n30 DGND 6.68e-19
C8818 DVDD.n31 DGND 0.003654f
C8819 DVDD.t372 DGND 0.002359f
C8820 DVDD.t200 DGND 0.00437f
C8821 DVDD.n32 DGND 0.004977f
C8822 DVDD.n33 DGND 0.002635f
C8823 DVDD.t752 DGND 0.004456f
C8824 DVDD.t405 DGND 0.004456f
C8825 DVDD.n34 DGND 0.003654f
C8826 DVDD.t230 DGND 0.004455f
C8827 DVDD.t114 DGND 0.00437f
C8828 DVDD.n35 DGND 0.005139f
C8829 DVDD.n36 DGND 0.003654f
C8830 DVDD.t1 DGND 0.00445f
C8831 DVDD.t69 DGND 4.69e-19
C8832 DVDD.t324 DGND 4.69e-19
C8833 DVDD.n37 DGND 9.72e-19
C8834 DVDD.n38 DGND 0.003043f
C8835 DVDD.n39 DGND 6.96e-19
C8836 DVDD.n40 DGND 0.003654f
C8837 DVDD.n41 DGND 0.003654f
C8838 DVDD.n42 DGND 0.003654f
C8839 DVDD.n43 DGND 8.44e-19
C8840 DVDD.n44 DGND 0.004756f
C8841 DVDD.n45 DGND 8.02e-19
C8842 DVDD.t322 DGND 0.002373f
C8843 DVDD.n46 DGND 0.002865f
C8844 DVDD.n47 DGND 9.92e-19
C8845 DVDD.n48 DGND 0.003654f
C8846 DVDD.n49 DGND 0.003654f
C8847 DVDD.n50 DGND 4.64e-19
C8848 DVDD.n51 DGND 0.006222f
C8849 DVDD.n52 DGND 0.006464f
C8850 DVDD.n53 DGND 0.006471f
C8851 DVDD.n54 DGND 0.003654f
C8852 DVDD.n55 DGND 0.003654f
C8853 DVDD.n56 DGND 0.003654f
C8854 DVDD.n57 DGND 0.001104f
C8855 DVDD.n58 DGND 0.006816f
C8856 DVDD.n59 DGND 7.17e-19
C8857 DVDD.n60 DGND 0.003531f
C8858 DVDD.n61 DGND 0.003654f
C8859 DVDD.n62 DGND 0.003654f
C8860 DVDD.n63 DGND 0.003654f
C8861 DVDD.n64 DGND 7.17e-19
C8862 DVDD.n65 DGND 0.00328f
C8863 DVDD.n66 DGND 7.24e-19
C8864 DVDD.t910 DGND 4.69e-19
C8865 DVDD.t370 DGND 4.69e-19
C8866 DVDD.n67 DGND 9.6e-19
C8867 DVDD.t679 DGND 4.69e-19
C8868 DVDD.t496 DGND 4.69e-19
C8869 DVDD.n68 DGND 9.6e-19
C8870 DVDD.n69 DGND 0.002225f
C8871 DVDD.n70 DGND 0.002394f
C8872 DVDD.n71 DGND 0.001013f
C8873 DVDD.n72 DGND 0.003654f
C8874 DVDD.n73 DGND 0.003654f
C8875 DVDD.n74 DGND 0.003654f
C8876 DVDD.n75 DGND 7.52e-19
C8877 DVDD.n76 DGND 0.00328f
C8878 DVDD.n77 DGND 7.24e-19
C8879 DVDD.t376 DGND 0.002385f
C8880 DVDD.t148 DGND 4.69e-19
C8881 DVDD.t681 DGND 4.69e-19
C8882 DVDD.n78 DGND 9.72e-19
C8883 DVDD.n79 DGND 0.005271f
C8884 DVDD.n80 DGND 7.81e-19
C8885 DVDD.n81 DGND 0.003654f
C8886 DVDD.n82 DGND 0.003654f
C8887 DVDD.n83 DGND 0.003654f
C8888 DVDD.n84 DGND 0.001294f
C8889 DVDD.n85 DGND 0.001294f
C8890 DVDD.t675 DGND 0.002373f
C8891 DVDD.n86 DGND 0.002746f
C8892 DVDD.n87 DGND 9.92e-19
C8893 DVDD.n88 DGND 0.003654f
C8894 DVDD.n89 DGND 0.003654f
C8895 DVDD.n90 DGND 7.88e-19
C8896 DVDD.n91 DGND 9.7e-19
C8897 DVDD.n92 DGND 0.012846f
C8898 DVDD.n93 DGND 9.7e-19
C8899 DVDD.n94 DGND 0.003654f
C8900 DVDD.n95 DGND 0.003654f
C8901 DVDD.n96 DGND 0.003654f
C8902 DVDD.t136 DGND 0.00437f
C8903 DVDD.n97 DGND 0.005033f
C8904 DVDD.t203 DGND 0.001701f
C8905 DVDD.t403 DGND 0.004371f
C8906 DVDD.n98 DGND 0.00586f
C8907 DVDD.n99 DGND 0.003654f
C8908 DVDD.t205 DGND 4.69e-19
C8909 DVDD.t466 DGND 4.69e-19
C8910 DVDD.n100 DGND 9.6e-19
C8911 DVDD.t637 DGND 0.002359f
C8912 DVDD.n101 DGND 0.001294f
C8913 DVDD.n102 DGND 0.003654f
C8914 DVDD.t464 DGND 0.002388f
C8915 DVDD.n103 DGND 0.003654f
C8916 DVDD.t639 DGND 4.69e-19
C8917 DVDD.t330 DGND 4.69e-19
C8918 DVDD.n104 DGND 9.72e-19
C8919 DVDD.t957 DGND 0.001067f
C8920 DVDD.t770 DGND 0.001477f
C8921 DVDD.n105 DGND 0.006432f
C8922 DVDD.t969 DGND 0.001573f
C8923 DVDD.t805 DGND 9.84e-19
C8924 DVDD.n106 DGND 0.00305f
C8925 DVDD.n107 DGND 0.011169f
C8926 DVDD.t963 DGND 0.00166f
C8927 DVDD.t817 DGND 8.91e-19
C8928 DVDD.n108 DGND 0.003043f
C8929 DVDD.n109 DGND 0.02705f
C8930 DVDD.t491 DGND 0.001701f
C8931 DVDD.n110 DGND 0.002807f
C8932 DVDD.n111 DGND 0.003654f
C8933 DVDD.t563 DGND 0.00437f
C8934 DVDD.n112 DGND 0.005146f
C8935 DVDD.t488 DGND 4.69e-19
C8936 DVDD.t635 DGND 4.69e-19
C8937 DVDD.n113 DGND 9.6e-19
C8938 DVDD.t513 DGND 0.004371f
C8939 DVDD.n114 DGND 0.00586f
C8940 DVDD.n115 DGND 0.003654f
C8941 DVDD.t732 DGND 0.00237f
C8942 DVDD.t641 DGND 0.002388f
C8943 DVDD.n116 DGND 0.003223f
C8944 DVDD.n117 DGND 0.003654f
C8945 DVDD.t734 DGND 4.69e-19
C8946 DVDD.t821 DGND 4.69e-19
C8947 DVDD.n118 DGND 9.6e-19
C8948 DVDD.n119 DGND 0.002591f
C8949 DVDD.n120 DGND 0.003654f
C8950 DVDD.t569 DGND 0.004371f
C8951 DVDD.t689 DGND 0.00437f
C8952 DVDD.t696 DGND 0.001701f
C8953 DVDD.n121 DGND 6.54e-19
C8954 DVDD.n122 DGND 0.003654f
C8955 DVDD.t366 DGND 0.00437f
C8956 DVDD.t698 DGND 4.69e-19
C8957 DVDD.t736 DGND 4.69e-19
C8958 DVDD.n123 DGND 9.6e-19
C8959 DVDD.t401 DGND 0.004371f
C8960 DVDD.n124 DGND 0.005579f
C8961 DVDD.n125 DGND 0.002563f
C8962 DVDD.n126 DGND 0.005118f
C8963 DVDD.t617 DGND 0.004455f
C8964 DVDD.n127 DGND 0.00573f
C8965 DVDD.t188 DGND 0.004587f
C8966 DVDD.t730 DGND 0.002388f
C8967 DVDD.n128 DGND 0.003317f
C8968 DVDD.n129 DGND 0.006633f
C8969 DVDD.n130 DGND 0.023501f
C8970 DVDD.n131 DGND 0.002422f
C8971 DVDD.t764 DGND 0.001477f
C8972 DVDD.t947 DGND 0.001067f
C8973 DVDD.n132 DGND 0.006432f
C8974 DVDD.t791 DGND 9.84e-19
C8975 DVDD.t965 DGND 0.001573f
C8976 DVDD.n133 DGND 0.00305f
C8977 DVDD.n134 DGND 0.011169f
C8978 DVDD.t766 DGND 8.91e-19
C8979 DVDD.t946 DGND 0.00166f
C8980 DVDD.n135 DGND 0.003043f
C8981 DVDD.n136 DGND 0.004956f
C8982 DVDD.n137 DGND 0.017513f
C8983 DVDD.n138 DGND 6.96e-19
C8984 DVDD.n139 DGND 0.003654f
C8985 DVDD.t712 DGND 4.69e-19
C8986 DVDD.t102 DGND 4.69e-19
C8987 DVDD.n140 DGND 9.6e-19
C8988 DVDD.t879 DGND 0.001701f
C8989 DVDD.n141 DGND 8.44e-19
C8990 DVDD.n142 DGND 0.003654f
C8991 DVDD.n143 DGND 0.001203f
C8992 DVDD.n144 DGND 0.003654f
C8993 DVDD.t98 DGND 0.002359f
C8994 DVDD.n145 DGND 0.002516f
C8995 DVDD.n146 DGND 0.003654f
C8996 DVDD.n147 DGND 6.68e-19
C8997 DVDD.n148 DGND 0.003654f
C8998 DVDD.t596 DGND 4.69e-19
C8999 DVDD.t273 DGND 4.69e-19
C9000 DVDD.n149 DGND 9.72e-19
C9001 DVDD.n150 DGND 0.00369f
C9002 DVDD.n151 DGND 0.003654f
C9003 DVDD.t557 DGND 0.001713f
C9004 DVDD.n152 DGND 0.00328f
C9005 DVDD.n153 DGND 0.003654f
C9006 DVDD.t598 DGND 0.002359f
C9007 DVDD.t384 DGND 4.69e-19
C9008 DVDD.t23 DGND 4.69e-19
C9009 DVDD.n154 DGND 9.6e-19
C9010 DVDD.n155 DGND 9.7e-19
C9011 DVDD.n156 DGND 0.003654f
C9012 DVDD.t106 DGND 0.004456f
C9013 DVDD.n157 DGND 0.006724f
C9014 DVDD.t534 DGND 0.104191f
C9015 DVDD.t118 DGND 0.019667f
C9016 DVDD.t844 DGND 0.017092f
C9017 DVDD.t759 DGND 0.011239f
C9018 DVDD.t891 DGND 0.012995f
C9019 DVDD.t536 DGND 0.020253f
C9020 DVDD.t845 DGND 0.019667f
C9021 DVDD.t119 DGND 0.031843f
C9022 DVDD.t123 DGND 0.031843f
C9023 DVDD.t540 DGND 0.019667f
C9024 DVDD.t843 DGND 0.015921f
C9025 DVDD.n158 DGND 9.7e-19
C9026 DVDD.n159 DGND 8.16e-19
C9027 DVDD.n160 DGND 0.003654f
C9028 DVDD.t120 DGND 0.001713f
C9029 DVDD.n161 DGND 0.00328f
C9030 DVDD.n162 DGND 0.003455f
C9031 DVDD.t760 DGND 0.00445f
C9032 DVDD.n163 DGND 0.005216f
C9033 DVDD.t535 DGND 0.002419f
C9034 DVDD.n164 DGND 0.028662f
C9035 DVDD.n165 DGND 0.017765f
C9036 DVDD.n166 DGND 0.003654f
C9037 DVDD.t33 DGND 0.004657f
C9038 DVDD.n167 DGND 0.021609f
C9039 DVDD.t667 DGND 0.00445f
C9040 DVDD.n168 DGND 0.005196f
C9041 DVDD.n169 DGND 8.02e-19
C9042 DVDD.n170 DGND 0.003654f
C9043 DVDD.t661 DGND 0.00237f
C9044 DVDD.n171 DGND 0.001294f
C9045 DVDD.n172 DGND 0.003654f
C9046 DVDD.n173 DGND 5.41e-19
C9047 DVDD.t32 DGND 0.117303f
C9048 DVDD.t666 DGND 0.079373f
C9049 DVDD.t660 DGND 0.0583f
C9050 DVDD.t231 DGND 0.019667f
C9051 DVDD.t804 DGND 0.019667f
C9052 DVDD.t34 DGND 0.013697f
C9053 DVDD.n174 DGND 9.63e-19
C9054 DVDD.n175 DGND 0.001153f
C9055 DVDD.n176 DGND 0.003654f
C9056 DVDD.t545 DGND 0.002373f
C9057 DVDD.t280 DGND 0.004455f
C9058 DVDD.n177 DGND 0.003654f
C9059 DVDD.t742 DGND 0.002388f
C9060 DVDD.n178 DGND 0.003223f
C9061 DVDD.n179 DGND 0.003654f
C9062 DVDD.t670 DGND 4.69e-19
C9063 DVDD.t547 DGND 4.69e-19
C9064 DVDD.n180 DGND 9.72e-19
C9065 DVDD.t673 DGND 0.001713f
C9066 DVDD.n181 DGND 0.00328f
C9067 DVDD.n182 DGND 0.003654f
C9068 DVDD.t246 DGND 4.69e-19
C9069 DVDD.t744 DGND 4.69e-19
C9070 DVDD.n183 DGND 9.72e-19
C9071 DVDD.t551 DGND 4.69e-19
C9072 DVDD.t449 DGND 4.69e-19
C9073 DVDD.n184 DGND 9.72e-19
C9074 DVDD.t249 DGND 0.001713f
C9075 DVDD.n185 DGND 0.00328f
C9076 DVDD.n186 DGND 0.003654f
C9077 DVDD.t740 DGND 4.69e-19
C9078 DVDD.t763 DGND 4.69e-19
C9079 DVDD.n187 DGND 9.72e-19
C9080 DVDD.t549 DGND 0.00237f
C9081 DVDD.n188 DGND 0.00396f
C9082 DVDD.n189 DGND 0.003654f
C9083 DVDD.t397 DGND 0.004456f
C9084 DVDD.t738 DGND 0.00237f
C9085 DVDD.n190 DGND 0.003654f
C9086 DVDD.n191 DGND 0.003654f
C9087 DVDD.t83 DGND 0.004455f
C9088 DVDD.t44 DGND 0.00445f
C9089 DVDD.n192 DGND 0.004756f
C9090 DVDD.n193 DGND 0.003654f
C9091 DVDD.t663 DGND 0.002388f
C9092 DVDD.t954 DGND 0.001067f
C9093 DVDD.t774 DGND 0.001477f
C9094 DVDD.n194 DGND 0.006432f
C9095 DVDD.t959 DGND 0.001573f
C9096 DVDD.t761 DGND 9.84e-19
C9097 DVDD.n195 DGND 0.00305f
C9098 DVDD.n196 DGND 0.011169f
C9099 DVDD.t968 DGND 0.00166f
C9100 DVDD.t808 DGND 8.91e-19
C9101 DVDD.n197 DGND 0.003043f
C9102 DVDD.n198 DGND 0.012217f
C9103 DVDD.n199 DGND 0.004632f
C9104 DVDD.n200 DGND 0.003654f
C9105 DVDD.t237 DGND 4.69e-19
C9106 DVDD.t659 DGND 4.69e-19
C9107 DVDD.n201 DGND 9.72e-19
C9108 DVDD.n202 DGND 7.24e-19
C9109 DVDD.n203 DGND 0.003654f
C9110 DVDD.t665 DGND 4.69e-19
C9111 DVDD.t783 DGND 4.69e-19
C9112 DVDD.n204 DGND 9.72e-19
C9113 DVDD.n205 DGND 0.00369f
C9114 DVDD.t235 DGND 0.001713f
C9115 DVDD.n206 DGND 0.00328f
C9116 DVDD.n207 DGND 7.17e-19
C9117 DVDD.n208 DGND 0.003654f
C9118 DVDD.n209 DGND 0.003654f
C9119 DVDD.n210 DGND 0.003654f
C9120 DVDD.n211 DGND 7.81e-19
C9121 DVDD.n212 DGND 0.003043f
C9122 DVDD.n213 DGND 6.96e-19
C9123 DVDD.n214 DGND 9.7e-19
C9124 DVDD.n215 DGND 0.003654f
C9125 DVDD.n216 DGND 0.003654f
C9126 DVDD.n217 DGND 9.7e-19
C9127 DVDD.n218 DGND 8.16e-19
C9128 DVDD.n219 DGND 0.003223f
C9129 DVDD.n220 DGND 3.23e-19
C9130 DVDD.n221 DGND 0.003654f
C9131 DVDD.n222 DGND 0.003654f
C9132 DVDD.n223 DGND 5.98e-19
C9133 DVDD.n224 DGND 0.006039f
C9134 DVDD.n225 DGND 0.003608f
C9135 DVDD.n226 DGND 0.006724f
C9136 DVDD.n227 DGND 7.17e-19
C9137 DVDD.n228 DGND 0.003654f
C9138 DVDD.n229 DGND 0.003654f
C9139 DVDD.n230 DGND 0.003654f
C9140 DVDD.n231 DGND 7.74e-19
C9141 DVDD.n232 DGND 0.00369f
C9142 DVDD.n233 DGND 7.17e-19
C9143 DVDD.n234 DGND 0.003654f
C9144 DVDD.n235 DGND 0.003654f
C9145 DVDD.n236 DGND 2.95e-19
C9146 DVDD.n237 DGND 0.003177f
C9147 DVDD.n238 DGND 0.003008f
C9148 DVDD.n239 DGND 1.55e-19
C9149 DVDD.n240 DGND 0.003654f
C9150 DVDD.n241 DGND 0.003654f
C9151 DVDD.n242 DGND 7.24e-19
C9152 DVDD.n243 DGND 7.81e-19
C9153 DVDD.n244 DGND 0.003043f
C9154 DVDD.n245 DGND 2.18e-19
C9155 DVDD.n246 DGND 0.003654f
C9156 DVDD.n247 DGND 0.003654f
C9157 DVDD.n248 DGND 5.7e-19
C9158 DVDD.n249 DGND 0.006412f
C9159 DVDD.n250 DGND 8.3e-19
C9160 DVDD.n251 DGND 0.002886f
C9161 DVDD.t721 DGND 0.004371f
C9162 DVDD.n252 DGND 0.00586f
C9163 DVDD.n253 DGND 3.09e-19
C9164 DVDD.n254 DGND 0.003654f
C9165 DVDD.n255 DGND 0.003654f
C9166 DVDD.n256 DGND 0.003654f
C9167 DVDD.t453 DGND 0.00437f
C9168 DVDD.t519 DGND 0.002359f
C9169 DVDD.n257 DGND 0.002839f
C9170 DVDD.n258 DGND 0.004977f
C9171 DVDD.n259 DGND 0.003654f
C9172 DVDD.t719 DGND 0.004456f
C9173 DVDD.t886 DGND 0.00237f
C9174 DVDD.n260 DGND 0.003531f
C9175 DVDD.n261 DGND 0.003654f
C9176 DVDD.t517 DGND 4.69e-19
C9177 DVDD.t483 DGND 4.69e-19
C9178 DVDD.n262 DGND 9.72e-19
C9179 DVDD.t475 DGND 0.001713f
C9180 DVDD.n263 DGND 0.001013f
C9181 DVDD.n264 DGND 0.003654f
C9182 DVDD.t888 DGND 4.69e-19
C9183 DVDD.t702 DGND 4.69e-19
C9184 DVDD.n265 DGND 9.6e-19
C9185 DVDD.t477 DGND 4.69e-19
C9186 DVDD.t521 DGND 4.69e-19
C9187 DVDD.n266 DGND 9.6e-19
C9188 DVDD.n267 DGND 0.002394f
C9189 DVDD.n268 DGND 0.002225f
C9190 DVDD.t874 DGND 0.001713f
C9191 DVDD.n269 DGND 7.81e-19
C9192 DVDD.n270 DGND 0.003654f
C9193 DVDD.t407 DGND 0.002385f
C9194 DVDD.t877 DGND 4.69e-19
C9195 DVDD.t884 DGND 4.69e-19
C9196 DVDD.n271 DGND 9.72e-19
C9197 DVDD.n272 DGND 0.005271f
C9198 DVDD.t228 DGND 0.004455f
C9199 DVDD.n273 DGND 6.54e-19
C9200 DVDD.n274 DGND 0.003654f
C9201 DVDD.t257 DGND 0.00437f
C9202 DVDD.t890 DGND 0.002373f
C9203 DVDD.t881 DGND 0.004371f
C9204 DVDD.n275 DGND 0.005557f
C9205 DVDD.n276 DGND 0.002858f
C9206 DVDD.n277 DGND 0.005139f
C9207 DVDD.t173 DGND 0.004371f
C9208 DVDD.n278 DGND 0.005557f
C9209 DVDD.n279 DGND 0.003654f
C9210 DVDD.t543 DGND 0.004368f
C9211 DVDD.n280 DGND 0.004536f
C9212 DVDD.t418 DGND 0.004456f
C9213 DVDD.n281 DGND 0.006612f
C9214 DVDD.n282 DGND 0.00383f
C9215 DVDD.t171 DGND 0.004456f
C9216 DVDD.n283 DGND 0.007175f
C9217 DVDD.n284 DGND 9.42e-19
C9218 DVDD.t108 DGND 0.004455f
C9219 DVDD.n285 DGND 0.006208f
C9220 DVDD.n286 DGND 0.003654f
C9221 DVDD.n287 DGND 0.003654f
C9222 DVDD.n288 DGND 0.003654f
C9223 DVDD.n289 DGND 9.42e-19
C9224 DVDD.t36 DGND 0.004455f
C9225 DVDD.n290 DGND 0.006412f
C9226 DVDD.n291 DGND 7.45e-19
C9227 DVDD.n292 DGND 0.003654f
C9228 DVDD.n293 DGND 0.003654f
C9229 DVDD.n294 DGND 6.54e-19
C9230 DVDD.n295 DGND 0.001294f
C9231 DVDD.n296 DGND 6.68e-19
C9232 DVDD.n297 DGND 0.003654f
C9233 DVDD.n298 DGND 0.003654f
C9234 DVDD.n299 DGND 0.003654f
C9235 DVDD.n300 DGND 0.001132f
C9236 DVDD.n301 DGND 0.006412f
C9237 DVDD.n302 DGND 4.92e-19
C9238 DVDD.n303 DGND 0.003654f
C9239 DVDD.n304 DGND 0.003654f
C9240 DVDD.n305 DGND 0.003654f
C9241 DVDD.n306 DGND 7.24e-19
C9242 DVDD.n307 DGND 0.00328f
C9243 DVDD.n308 DGND 7.52e-19
C9244 DVDD.n309 DGND 8.44e-19
C9245 DVDD.n310 DGND 0.003654f
C9246 DVDD.n311 DGND 0.003654f
C9247 DVDD.n312 DGND 0.003654f
C9248 DVDD.n313 DGND 7.24e-19
C9249 DVDD.n314 DGND 0.00328f
C9250 DVDD.n315 DGND 7.17e-19
C9251 DVDD.n316 DGND 0.003599f
C9252 DVDD.n317 DGND 0.003654f
C9253 DVDD.n318 DGND 0.003654f
C9254 DVDD.n319 DGND 0.003654f
C9255 DVDD.n320 DGND 7.17e-19
C9256 DVDD.n321 DGND 0.006816f
C9257 DVDD.n322 DGND 0.001104f
C9258 DVDD.n323 DGND 6.68e-19
C9259 DVDD.n324 DGND 0.003654f
C9260 DVDD.n325 DGND 0.003654f
C9261 DVDD.n326 DGND 0.003654f
C9262 DVDD.n327 DGND 9.7e-19
C9263 DVDD.n328 DGND 0.009957f
C9264 DVDD.t170 DGND 0.084758f
C9265 DVDD.t107 DGND 0.032311f
C9266 DVDD.t417 DGND 0.032311f
C9267 DVDD.t35 DGND 0.036643f
C9268 DVDD.t542 DGND 0.033248f
C9269 DVDD.t172 DGND 0.016273f
C9270 DVDD.t256 DGND 0.028096f
C9271 DVDD.t889 DGND 0.022477f
C9272 DVDD.t880 DGND 0.010536f
C9273 DVDD.t872 DGND 0.009834f
C9274 DVDD.t227 DGND 0.009834f
C9275 DVDD.t700 DGND 0.016155f
C9276 DVDD.t883 DGND 0.019667f
C9277 DVDD.t876 DGND 0.012878f
C9278 DVDD.t406 DGND 0.01358f
C9279 DVDD.t473 DGND 0.018965f
C9280 DVDD.t873 DGND 0.009834f
C9281 DVDD.t485 DGND 0.009834f
C9282 DVDD.t701 DGND 0.009834f
C9283 DVDD.t520 DGND 0.009834f
C9284 DVDD.t887 DGND 0.009834f
C9285 DVDD.t476 DGND 0.010419f
C9286 DVDD.t451 DGND 0.020253f
C9287 DVDD.t703 DGND 0.012995f
C9288 DVDD.t474 DGND 0.008429f
C9289 DVDD.t875 DGND 0.009834f
C9290 DVDD.t482 DGND 0.011239f
C9291 DVDD.t885 DGND 0.009834f
C9292 DVDD.t516 DGND 0.012175f
C9293 DVDD.t274 DGND 0.021658f
C9294 DVDD.t613 DGND 0.019667f
C9295 DVDD.t472 DGND 0.008546f
C9296 DVDD.t718 DGND 0.009951f
C9297 DVDD.t452 DGND 0.011122f
C9298 DVDD.t518 DGND 0.032545f
C9299 DVDD.n329 DGND 0.060715f
C9300 DVDD.t720 DGND 0.028799f
C9301 DVDD.t544 DGND 0.009834f
C9302 DVDD.t279 DGND 0.010536f
C9303 DVDD.t671 DGND 0.017092f
C9304 DVDD.t447 DGND 0.019667f
C9305 DVDD.t546 DGND 0.011941f
C9306 DVDD.t741 DGND 0.009834f
C9307 DVDD.t669 DGND 0.010536f
C9308 DVDD.t250 DGND 0.012643f
C9309 DVDD.t775 DGND 0.019199f
C9310 DVDD.t672 DGND 0.009834f
C9311 DVDD.t743 DGND 0.009834f
C9312 DVDD.t448 DGND 0.009834f
C9313 DVDD.t245 DGND 0.009834f
C9314 DVDD.t550 DGND 0.019785f
C9315 DVDD.t232 DGND 0.012643f
C9316 DVDD.t248 DGND 0.011239f
C9317 DVDD.t450 DGND 0.009834f
C9318 DVDD.t762 DGND 0.008429f
C9319 DVDD.t668 DGND 0.009834f
C9320 DVDD.t739 DGND 0.011239f
C9321 DVDD.t548 DGND 0.010419f
C9322 DVDD.t471 DGND 0.012643f
C9323 DVDD.t809 DGND 0.019667f
C9324 DVDD.t247 DGND 0.019316f
C9325 DVDD.t396 DGND 0.011239f
C9326 DVDD.t737 DGND 0.009834f
C9327 DVDD.t82 DGND 0.036291f
C9328 DVDD.t43 DGND 0.039803f
C9329 DVDD.t662 DGND 0.023531f
C9330 DVDD.t233 DGND 0.02037f
C9331 DVDD.t811 DGND 0.019667f
C9332 DVDD.t658 DGND 0.019667f
C9333 DVDD.t236 DGND 0.031843f
C9334 DVDD.t234 DGND 0.031843f
C9335 DVDD.t782 DGND 0.019667f
C9336 DVDD.t664 DGND 0.017794f
C9337 DVDD.n330 DGND 0.014026f
C9338 DVDD.n331 DGND 0.005302f
C9339 DVDD.n332 DGND 9.7e-19
C9340 DVDD.n333 DGND 0.003654f
C9341 DVDD.n334 DGND 0.003654f
C9342 DVDD.n335 DGND 0.003654f
C9343 DVDD.n336 DGND 0.001203f
C9344 DVDD.n337 DGND 0.00396f
C9345 DVDD.n338 DGND 9.21e-19
C9346 DVDD.n339 DGND 0.001294f
C9347 DVDD.n340 DGND 0.003455f
C9348 DVDD.n341 DGND 0.012629f
C9349 DVDD.n342 DGND 0.077519f
C9350 DVDD.n343 DGND 0.001827f
C9351 DVDD.n344 DGND 0.009238f
C9352 DVDD.n345 DGND 3.73e-19
C9353 DVDD.t537 DGND 4.69e-19
C9354 DVDD.t846 DGND 4.69e-19
C9355 DVDD.n346 DGND 9.72e-19
C9356 DVDD.n347 DGND 0.00369f
C9357 DVDD.n348 DGND 7.17e-19
C9358 DVDD.n349 DGND 0.003654f
C9359 DVDD.n350 DGND 0.003654f
C9360 DVDD.n351 DGND 7.24e-19
C9361 DVDD.n352 DGND 7.81e-19
C9362 DVDD.t124 DGND 4.69e-19
C9363 DVDD.t541 DGND 4.69e-19
C9364 DVDD.n353 DGND 9.72e-19
C9365 DVDD.n354 DGND 0.003043f
C9366 DVDD.n355 DGND 6.96e-19
C9367 DVDD.n356 DGND 0.003654f
C9368 DVDD.n357 DGND 0.003654f
C9369 DVDD.n358 DGND 0.003654f
C9370 DVDD.t539 DGND 0.002388f
C9371 DVDD.n359 DGND 0.003223f
C9372 DVDD.t810 DGND 0.001477f
C9373 DVDD.t950 DGND 0.001067f
C9374 DVDD.n360 DGND 0.006432f
C9375 DVDD.t781 DGND 9.84e-19
C9376 DVDD.t967 DGND 0.001573f
C9377 DVDD.n361 DGND 0.00305f
C9378 DVDD.n362 DGND 0.011169f
C9379 DVDD.t803 DGND 8.91e-19
C9380 DVDD.t956 DGND 0.00166f
C9381 DVDD.n363 DGND 0.003043f
C9382 DVDD.n364 DGND 0.020613f
C9383 DVDD.t923 DGND 0.002359f
C9384 DVDD.t198 DGND 0.00437f
C9385 DVDD.n365 DGND 0.001104f
C9386 DVDD.n366 DGND 0.003654f
C9387 DVDD.t929 DGND 4.69e-19
C9388 DVDD.t575 DGND 4.69e-19
C9389 DVDD.n367 DGND 9.72e-19
C9390 DVDD.n368 DGND 0.003599f
C9391 DVDD.t838 DGND 0.00237f
C9392 DVDD.n369 DGND 0.003654f
C9393 DVDD.t268 DGND 4.69e-19
C9394 DVDD.t927 DGND 4.69e-19
C9395 DVDD.n370 DGND 9.6e-19
C9396 DVDD.n371 DGND 0.002394f
C9397 DVDD.n372 DGND 0.003654f
C9398 DVDD.t842 DGND 4.69e-19
C9399 DVDD.t816 DGND 4.69e-19
C9400 DVDD.n373 DGND 9.6e-19
C9401 DVDD.n374 DGND 0.002225f
C9402 DVDD.n375 DGND 7.81e-19
C9403 DVDD.n376 DGND 0.003654f
C9404 DVDD.t687 DGND 4.69e-19
C9405 DVDD.t836 DGND 4.69e-19
C9406 DVDD.n377 DGND 9.72e-19
C9407 DVDD.t925 DGND 0.002385f
C9408 DVDD.n378 DGND 0.005271f
C9409 DVDD.n379 DGND 6.54e-19
C9410 DVDD.n380 DGND 0.003654f
C9411 DVDD.t840 DGND 0.002373f
C9412 DVDD.t523 DGND 0.004371f
C9413 DVDD.n381 DGND 0.005557f
C9414 DVDD.n382 DGND 0.002879f
C9415 DVDD.t948 DGND 0.001067f
C9416 DVDD.t787 DGND 0.001477f
C9417 DVDD.n383 DGND 0.006432f
C9418 DVDD.t966 DGND 0.001573f
C9419 DVDD.t814 DGND 9.84e-19
C9420 DVDD.n384 DGND 0.00305f
C9421 DVDD.n385 DGND 0.011169f
C9422 DVDD.t955 DGND 0.00166f
C9423 DVDD.t772 DGND 8.91e-19
C9424 DVDD.n386 DGND 0.003043f
C9425 DVDD.n387 DGND 0.018193f
C9426 DVDD.n388 DGND 9.42e-19
C9427 DVDD.t856 DGND 0.004455f
C9428 DVDD.n389 DGND 0.003654f
C9429 DVDD.t382 DGND 0.00237f
C9430 DVDD.n390 DGND 0.003654f
C9431 DVDD.n391 DGND 0.003608f
C9432 DVDD.t278 DGND 0.004455f
C9433 DVDD.n392 DGND 0.005835f
C9434 DVDD.t192 DGND 0.004456f
C9435 DVDD.t717 DGND 0.004456f
C9436 DVDD.n393 DGND 0.01174f
C9437 DVDD.n394 DGND 0.003654f
C9438 DVDD.n395 DGND 0.003654f
C9439 DVDD.n396 DGND 0.003654f
C9440 DVDD.t334 DGND 0.004455f
C9441 DVDD.n397 DGND 0.011164f
C9442 DVDD.n398 DGND 7.67e-19
C9443 DVDD.n399 DGND 0.008974f
C9444 DVDD.n400 DGND 6.26e-19
C9445 DVDD.n401 DGND 0.003654f
C9446 DVDD.n402 DGND 0.003654f
C9447 DVDD.n403 DGND 0.003654f
C9448 DVDD.n404 DGND 0.001132f
C9449 DVDD.t493 DGND 0.004455f
C9450 DVDD.n405 DGND 0.006412f
C9451 DVDD.n406 DGND 4.92e-19
C9452 DVDD.n407 DGND 0.003654f
C9453 DVDD.n408 DGND 0.003654f
C9454 DVDD.n409 DGND 0.003654f
C9455 DVDD.n410 DGND 7.24e-19
C9456 DVDD.t685 DGND 0.001713f
C9457 DVDD.n411 DGND 0.00328f
C9458 DVDD.n412 DGND 7.52e-19
C9459 DVDD.n413 DGND 8.44e-19
C9460 DVDD.n414 DGND 0.003654f
C9461 DVDD.n415 DGND 0.003654f
C9462 DVDD.n416 DGND 0.001013f
C9463 DVDD.n417 DGND 7.24e-19
C9464 DVDD.t266 DGND 0.001713f
C9465 DVDD.n418 DGND 0.00328f
C9466 DVDD.n419 DGND 7.17e-19
C9467 DVDD.n420 DGND 0.003654f
C9468 DVDD.n421 DGND 0.003654f
C9469 DVDD.n422 DGND 0.003654f
C9470 DVDD.n423 DGND 0.003531f
C9471 DVDD.n424 DGND 7.17e-19
C9472 DVDD.t104 DGND 0.004456f
C9473 DVDD.n425 DGND 0.006816f
C9474 DVDD.n426 DGND 0.003654f
C9475 DVDD.n427 DGND 0.003654f
C9476 DVDD.n428 DGND 0.003654f
C9477 DVDD.n429 DGND 6.68e-19
C9478 DVDD.n430 DGND 0.004977f
C9479 DVDD.n431 DGND 0.002839f
C9480 DVDD.n432 DGND 8.3e-19
C9481 DVDD.n433 DGND 0.007917f
C9482 DVDD.n434 DGND 4.5e-19
C9483 DVDD.n435 DGND 0.003654f
C9484 DVDD.n436 DGND 0.003654f
C9485 DVDD.n437 DGND 0.003654f
C9486 DVDD.n438 DGND 9.7e-19
C9487 DVDD.n439 DGND 0.005302f
C9488 DVDD.n440 DGND 0.013441f
C9489 DVDD.t121 DGND 0.014282f
C9490 DVDD.t538 DGND 0.049052f
C9491 DVDD.t922 DGND 0.039803f
C9492 DVDD.t197 DGND 0.011122f
C9493 DVDD.t103 DGND 0.009951f
C9494 DVDD.t269 DGND 0.008546f
C9495 DVDD.t576 DGND 0.019667f
C9496 DVDD.t122 DGND 0.021658f
C9497 DVDD.t928 DGND 0.012175f
C9498 DVDD.t837 DGND 0.009834f
C9499 DVDD.t574 DGND 0.011239f
C9500 DVDD.t683 DGND 0.009834f
C9501 DVDD.t265 DGND 0.008429f
C9502 DVDD.t773 DGND 0.012995f
C9503 DVDD.t391 DGND 0.020253f
C9504 DVDD.t267 DGND 0.010419f
C9505 DVDD.t841 DGND 0.009834f
C9506 DVDD.t926 DGND 0.009834f
C9507 DVDD.t815 DGND 0.009834f
C9508 DVDD.t573 DGND 0.009834f
C9509 DVDD.t684 DGND 0.009834f
C9510 DVDD.t264 DGND 0.018965f
C9511 DVDD.t924 DGND 0.01358f
C9512 DVDD.t686 DGND 0.012878f
C9513 DVDD.t835 DGND 0.019667f
C9514 DVDD.t788 DGND 0.016155f
C9515 DVDD.t492 DGND 0.009834f
C9516 DVDD.t682 DGND 0.009834f
C9517 DVDD.t522 DGND 0.010536f
C9518 DVDD.t839 DGND 0.044018f
C9519 DVDD.t333 DGND 0.049637f
C9520 DVDD.t191 DGND 0.032311f
C9521 DVDD.t277 DGND 0.03196f
C9522 DVDD.t381 DGND 0.009834f
C9523 DVDD.t105 DGND 0.011239f
C9524 DVDD.t554 DGND 0.019316f
C9525 DVDD.t24 DGND 0.011356f
C9526 DVDD.t61 DGND 0.055491f
C9527 DVDD.t186 DGND 0.02037f
C9528 DVDD.t765 DGND 0.011005f
C9529 DVDD.t95 DGND 0.009834f
C9530 DVDD.t59 DGND 0.010536f
C9531 DVDD.t714 DGND 0.009834f
C9532 DVDD.t618 DGND 0.009834f
C9533 DVDD.t86 DGND 0.011707f
C9534 DVDD.t101 DGND 0.019667f
C9535 DVDD.t711 DGND 0.010302f
C9536 DVDD.t878 DGND 0.010302f
C9537 DVDD.t792 DGND 0.019667f
C9538 DVDD.t65 DGND 0.011707f
C9539 DVDD.t709 DGND 0.010419f
C9540 DVDD.t713 DGND 0.009834f
C9541 DVDD.t609 DGND 0.011122f
C9542 DVDD.t99 DGND 0.009951f
C9543 DVDD.t767 DGND 0.008546f
C9544 DVDD.t115 DGND 0.010302f
C9545 DVDD.t251 DGND 0.011239f
C9546 DVDD.t63 DGND 0.011239f
C9547 DVDD.t37 DGND 0.010302f
C9548 DVDD.t715 DGND 0.019667f
C9549 DVDD.t97 DGND 0.028214f
C9550 DVDD.t80 DGND 0.027511f
C9551 DVDD.t594 DGND 0.014985f
C9552 DVDD.t514 DGND 0.009834f
C9553 DVDD.t271 DGND 0.009834f
C9554 DVDD.t854 DGND 0.009834f
C9555 DVDD.t16 DGND 0.015219f
C9556 DVDD.t478 DGND 0.023648f
C9557 DVDD.t377 DGND 0.022009f
C9558 DVDD.t592 DGND 0.010536f
C9559 DVDD.t555 DGND 0.009834f
C9560 DVDD.t272 DGND 0.009834f
C9561 DVDD.t25 DGND 0.009834f
C9562 DVDD.t595 DGND 0.009834f
C9563 DVDD.t379 DGND 0.010419f
C9564 DVDD.t411 DGND 0.009834f
C9565 DVDD.t552 DGND 0.011239f
C9566 DVDD.t270 DGND 0.017912f
C9567 DVDD.t364 DGND 0.012526f
C9568 DVDD.t556 DGND 0.011239f
C9569 DVDD.t597 DGND 0.009834f
C9570 DVDD.t22 DGND 0.012526f
C9571 DVDD.t383 DGND 0.020253f
C9572 DVDD.t572 DGND 0.018731f
C9573 DVDD.n441 DGND 0.014846f
C9574 DVDD.n442 DGND 0.005302f
C9575 DVDD.n443 DGND 7.67e-19
C9576 DVDD.n444 DGND 0.003654f
C9577 DVDD.n445 DGND 0.003654f
C9578 DVDD.n446 DGND 0.003654f
C9579 DVDD.n447 DGND 0.001097f
C9580 DVDD.n448 DGND 0.00245f
C9581 DVDD.n449 DGND 0.00241f
C9582 DVDD.n450 DGND 7.88e-19
C9583 DVDD.n451 DGND 7.52e-19
C9584 DVDD.n452 DGND 0.003654f
C9585 DVDD.n453 DGND 0.003654f
C9586 DVDD.n454 DGND 7.24e-19
C9587 DVDD.n455 DGND 7.81e-19
C9588 DVDD.t553 DGND 4.69e-19
C9589 DVDD.t380 DGND 4.69e-19
C9590 DVDD.n456 DGND 9.72e-19
C9591 DVDD.n457 DGND 0.003043f
C9592 DVDD.n458 DGND 2.67e-19
C9593 DVDD.n459 DGND 0.003654f
C9594 DVDD.n460 DGND 0.003654f
C9595 DVDD.n461 DGND 0.003654f
C9596 DVDD.n462 DGND 7.17e-19
C9597 DVDD.t593 DGND 0.001713f
C9598 DVDD.n463 DGND 0.00328f
C9599 DVDD.n464 DGND 2.46e-19
C9600 DVDD.t378 DGND 0.002388f
C9601 DVDD.n465 DGND 0.003223f
C9602 DVDD.t479 DGND 4.69e-19
C9603 DVDD.t17 DGND 4.69e-19
C9604 DVDD.n466 DGND 9.6e-19
C9605 DVDD.t855 DGND 0.00437f
C9606 DVDD.n467 DGND 0.005118f
C9607 DVDD.n468 DGND 0.00257f
C9608 DVDD.n469 DGND 4.92e-19
C9609 DVDD.n470 DGND 0.003654f
C9610 DVDD.n471 DGND 0.003654f
C9611 DVDD.n472 DGND 0.003654f
C9612 DVDD.n473 DGND 0.001104f
C9613 DVDD.t515 DGND 0.004456f
C9614 DVDD.n474 DGND 0.006816f
C9615 DVDD.t81 DGND 0.002373f
C9616 DVDD.n475 DGND 0.002746f
C9617 DVDD.n476 DGND 7.88e-19
C9618 DVDD.n477 DGND 0.003654f
C9619 DVDD.n478 DGND 0.003654f
C9620 DVDD.n479 DGND 7.88e-19
C9621 DVDD.n480 DGND 9.21e-19
C9622 DVDD.t64 DGND 0.00237f
C9623 DVDD.n481 DGND 0.00396f
C9624 DVDD.n482 DGND 0.003654f
C9625 DVDD.n483 DGND 0.003654f
C9626 DVDD.n484 DGND 0.003654f
C9627 DVDD.n485 DGND 8.65e-19
C9628 DVDD.t100 DGND 4.69e-19
C9629 DVDD.t610 DGND 4.69e-19
C9630 DVDD.n486 DGND 9.72e-19
C9631 DVDD.n487 DGND 0.00369f
C9632 DVDD.t710 DGND 0.001701f
C9633 DVDD.t66 DGND 4.69e-19
C9634 DVDD.t793 DGND 4.69e-19
C9635 DVDD.n488 DGND 9.6e-19
C9636 DVDD.n489 DGND 0.002253f
C9637 DVDD.n490 DGND 0.002631f
C9638 DVDD.n491 DGND 9.49e-19
C9639 DVDD.n492 DGND 0.003654f
C9640 DVDD.n493 DGND 0.003654f
C9641 DVDD.n494 DGND 0.003654f
C9642 DVDD.n495 DGND 9.85e-19
C9643 DVDD.n496 DGND 0.002547f
C9644 DVDD.n497 DGND 0.002253f
C9645 DVDD.n498 DGND 9.28e-19
C9646 DVDD.t619 DGND 4.69e-19
C9647 DVDD.t60 DGND 4.69e-19
C9648 DVDD.n499 DGND 9.72e-19
C9649 DVDD.n500 DGND 0.003043f
C9650 DVDD.n501 DGND 7.81e-19
C9651 DVDD.n502 DGND 0.003654f
C9652 DVDD.n503 DGND 0.003654f
C9653 DVDD.n504 DGND 0.003654f
C9654 DVDD.n505 DGND 8.16e-19
C9655 DVDD.t96 DGND 0.002388f
C9656 DVDD.n506 DGND 0.003223f
C9657 DVDD.n507 DGND 7.74e-19
C9658 DVDD.t62 DGND 0.002388f
C9659 DVDD.n508 DGND 8.29e-19
C9660 DVDD.n509 DGND 8.16e-19
C9661 DVDD.n510 DGND 0.003058f
C9662 DVDD.n511 DGND 0.001827f
C9663 DVDD.n512 DGND 0.077629f
C9664 DVDD.n513 DGND 0.002422f
C9665 DVDD.t567 DGND 0.004379f
C9666 DVDD.n514 DGND 0.005722f
C9667 DVDD.n515 DGND 9.42e-19
C9668 DVDD.t419 DGND 0.004456f
C9669 DVDD.n516 DGND 0.003654f
C9670 DVDD.t190 DGND 0.004371f
C9671 DVDD.t901 DGND 0.002373f
C9672 DVDD.t416 DGND 0.004455f
C9673 DVDD.n517 DGND 0.006208f
C9674 DVDD.n518 DGND 0.003654f
C9675 DVDD.t293 DGND 4.69e-19
C9676 DVDD.t903 DGND 4.69e-19
C9677 DVDD.n519 DGND 9.6e-19
C9678 DVDD.t502 DGND 0.00437f
C9679 DVDD.n520 DGND 0.005476f
C9680 DVDD.n521 DGND 0.003654f
C9681 DVDD.t291 DGND 0.001701f
C9682 DVDD.t318 DGND 0.00437f
C9683 DVDD.n522 DGND 0.005033f
C9684 DVDD.n523 DGND 0.003654f
C9685 DVDD.n524 DGND 0.001294f
C9686 DVDD.n525 DGND 0.003654f
C9687 DVDD.t899 DGND 0.002359f
C9688 DVDD.t728 DGND 4.69e-19
C9689 DVDD.t126 DGND 4.69e-19
C9690 DVDD.n526 DGND 9.6e-19
C9691 DVDD.t88 DGND 0.002385f
C9692 DVDD.t725 DGND 0.001713f
C9693 DVDD.n527 DGND 0.005508f
C9694 DVDD.n528 DGND 0.003654f
C9695 DVDD.n529 DGND 6.96e-19
C9696 DVDD.n530 DGND 0.003654f
C9697 DVDD.t94 DGND 4.69e-19
C9698 DVDD.t79 DGND 4.69e-19
C9699 DVDD.n531 DGND 9.72e-19
C9700 DVDD.n532 DGND 0.003317f
C9701 DVDD.n533 DGND 0.003654f
C9702 DVDD.t566 DGND 0.036174f
C9703 DVDD.t912 DGND 0.009834f
C9704 DVDD.t753 DGND 0.027979f
C9705 DVDD.t168 DGND 0.032311f
C9706 DVDD.t252 DGND 0.032311f
C9707 DVDD.t189 DGND 0.029033f
C9708 DVDD.t900 DGND 0.009834f
C9709 DVDD.t415 DGND 0.010536f
C9710 DVDD.t294 DGND 0.017092f
C9711 DVDD.t746 DGND 0.015219f
C9712 DVDD.t193 DGND 0.009834f
C9713 DVDD.t902 DGND 0.009834f
C9714 DVDD.t501 DGND 0.009834f
C9715 DVDD.t292 DGND 0.022477f
C9716 DVDD.t331 DGND 0.022009f
C9717 DVDD.t290 DGND 0.009834f
C9718 DVDD.t317 DGND 0.009834f
C9719 DVDD.t747 DGND 0.013814f
C9720 DVDD.t904 DGND 0.020253f
C9721 DVDD.t140 DGND 0.015219f
C9722 DVDD.t131 DGND 0.011239f
C9723 DVDD.t745 DGND 0.010536f
C9724 DVDD.t723 DGND 0.008429f
C9725 DVDD.t295 DGND 0.009834f
C9726 DVDD.t431 DGND 0.011239f
C9727 DVDD.t898 DGND 0.009834f
C9728 DVDD.t125 DGND 0.013931f
C9729 DVDD.t727 DGND 0.031843f
C9730 DVDD.t724 DGND 0.024584f
C9731 DVDD.t87 DGND 0.009834f
C9732 DVDD.t432 DGND 0.010536f
C9733 DVDD.t45 DGND 0.009834f
C9734 DVDD.t129 DGND 0.009834f
C9735 DVDD.t77 DGND 0.010419f
C9736 DVDD.t315 DGND 0.009834f
C9737 DVDD.t89 DGND 0.011239f
C9738 DVDD.t430 DGND 0.009834f
C9739 DVDD.t48 DGND 0.008429f
C9740 DVDD.t722 DGND 0.01838f
C9741 DVDD.t127 DGND 0.014868f
C9742 DVDD.t46 DGND 0.013463f
C9743 DVDD.t78 DGND 0.019667f
C9744 DVDD.t93 DGND 0.017794f
C9745 DVDD.n534 DGND 0.014026f
C9746 DVDD.n535 DGND 0.003654f
C9747 DVDD.t500 DGND 0.004456f
C9748 DVDD.n536 DGND 6.68e-19
C9749 DVDD.n537 DGND 0.003654f
C9750 DVDD.t525 DGND 0.004456f
C9751 DVDD.t631 DGND 0.002388f
C9752 DVDD.n538 DGND 0.003061f
C9753 DVDD.n539 DGND 0.003654f
C9754 DVDD.t226 DGND 0.004455f
C9755 DVDD.t301 DGND 0.002388f
C9756 DVDD.n540 DGND 6.96e-19
C9757 DVDD.n541 DGND 0.003654f
C9758 DVDD.t155 DGND 4.69e-19
C9759 DVDD.t297 DGND 4.69e-19
C9760 DVDD.n542 DGND 9.6e-19
C9761 DVDD.t3 DGND 0.001701f
C9762 DVDD.n543 DGND 8.44e-19
C9763 DVDD.n544 DGND 0.003654f
C9764 DVDD.t303 DGND 4.69e-19
C9765 DVDD.t19 DGND 4.69e-19
C9766 DVDD.n545 DGND 9.72e-19
C9767 DVDD.n546 DGND 0.001203f
C9768 DVDD.n547 DGND 0.003654f
C9769 DVDD.t627 DGND 0.00237f
C9770 DVDD.t299 DGND 0.002359f
C9771 DVDD.n548 DGND 0.002516f
C9772 DVDD.n549 DGND 0.003654f
C9773 DVDD.t393 DGND 0.004456f
C9774 DVDD.n550 DGND 6.68e-19
C9775 DVDD.n551 DGND 0.003654f
C9776 DVDD.t387 DGND 0.001701f
C9777 DVDD.t504 DGND 0.00437f
C9778 DVDD.n552 DGND 0.005483f
C9779 DVDD.n553 DGND 0.003654f
C9780 DVDD.t834 DGND 4.69e-19
C9781 DVDD.t446 DGND 4.69e-19
C9782 DVDD.n554 DGND 9.6e-19
C9783 DVDD.t75 DGND 0.00445f
C9784 DVDD.n555 DGND 0.004756f
C9785 DVDD.n556 DGND 0.003654f
C9786 DVDD.t565 DGND 0.004371f
C9787 DVDD.t830 DGND 0.002359f
C9788 DVDD.n557 DGND 0.00286f
C9789 DVDD.n558 DGND 0.001827f
C9790 DVDD.t615 DGND 0.00437f
C9791 DVDD.n559 DGND 0.005139f
C9792 DVDD.n560 DGND 0.01811f
C9793 DVDD.t110 DGND 0.004621f
C9794 DVDD.n561 DGND 0.013206f
C9795 DVDD.t196 DGND 0.004456f
C9796 DVDD.n562 DGND 0.006993f
C9797 DVDD.n563 DGND 0.00109f
C9798 DVDD.t421 DGND 0.004368f
C9799 DVDD.n564 DGND 0.004522f
C9800 DVDD.n565 DGND 9.92e-19
C9801 DVDD.n566 DGND 0.003654f
C9802 DVDD.n567 DGND 0.002025f
C9803 DVDD.n568 DGND 6.68e-19
C9804 DVDD.n569 DGND 0.001153f
C9805 DVDD.n570 DGND 0.003455f
C9806 DVDD.n571 DGND 0.003654f
C9807 DVDD.n572 DGND 1.48e-19
C9808 DVDD.n573 DGND 0.00586f
C9809 DVDD.n574 DGND 0.001287f
C9810 DVDD.n575 DGND 8.44e-19
C9811 DVDD.n576 DGND 0.003654f
C9812 DVDD.n577 DGND 0.003654f
C9813 DVDD.n578 DGND 8.02e-19
C9814 DVDD.n579 DGND 9.7e-19
C9815 DVDD.t109 DGND 0.083821f
C9816 DVDD.t195 DGND 0.037813f
C9817 DVDD.t420 DGND 0.044018f
C9818 DVDD.t614 DGND 0.025872f
C9819 DVDD.t564 DGND 0.020253f
C9820 DVDD.t829 DGND 0.021658f
C9821 DVDD.t388 DGND 0.01756f
C9822 DVDD.t74 DGND 0.008429f
C9823 DVDD.t442 DGND 0.013346f
C9824 DVDD.t67 DGND 0.021658f
C9825 DVDD.t833 DGND 0.013229f
C9826 DVDD.t444 DGND 0.013697f
C9827 DVDD.t76 DGND 0.019667f
C9828 DVDD.t50 DGND 0.008546f
C9829 DVDD.t499 DGND 0.009951f
C9830 DVDD.t367 DGND 0.011122f
C9831 DVDD.t91 DGND 0.033248f
C9832 DVDD.t524 DGND 0.041793f
C9833 DVDD.t225 DGND 0.017326f
C9834 DVDD.t630 DGND 0.018029f
C9835 DVDD.t5 DGND 0.02037f
C9836 DVDD.t141 DGND 0.011005f
C9837 DVDD.t300 DGND 0.009834f
C9838 DVDD.t624 DGND 0.010536f
C9839 DVDD.t150 DGND 0.009834f
C9840 DVDD.t6 DGND 0.009834f
C9841 DVDD.t21 DGND 0.011707f
C9842 DVDD.t296 DGND 0.019667f
C9843 DVDD.t154 DGND 0.010302f
C9844 DVDD.t2 DGND 0.010302f
C9845 DVDD.t138 DGND 0.019667f
C9846 DVDD.t628 DGND 0.011707f
C9847 DVDD.t152 DGND 0.010419f
C9848 DVDD.t853 DGND 0.009834f
C9849 DVDD.t18 DGND 0.011122f
C9850 DVDD.t302 DGND 0.009951f
C9851 DVDD.t137 DGND 0.008546f
C9852 DVDD.t8 DGND 0.010302f
C9853 DVDD.t4 DGND 0.011239f
C9854 DVDD.t626 DGND 0.011239f
C9855 DVDD.t20 DGND 0.010302f
C9856 DVDD.t151 DGND 0.019667f
C9857 DVDD.t298 DGND 0.028214f
C9858 DVDD.t831 DGND 0.027511f
C9859 DVDD.t385 DGND 0.014985f
C9860 DVDD.t392 DGND 0.009834f
C9861 DVDD.t443 DGND 0.009834f
C9862 DVDD.t398 DGND 0.009834f
C9863 DVDD.t827 DGND 0.015219f
C9864 DVDD.t389 DGND 0.017092f
C9865 DVDD.t749 DGND 0.017092f
C9866 DVDD.t503 DGND 0.014751f
C9867 DVDD.t386 DGND 0.014751f
C9868 DVDD.t445 DGND 0.016858f
C9869 DVDD.n580 DGND 0.013441f
C9870 DVDD.n581 DGND 0.005105f
C9871 DVDD.n582 DGND 0.002267f
C9872 DVDD.n583 DGND 8.23e-19
C9873 DVDD.n584 DGND 0.003654f
C9874 DVDD.n585 DGND 0.003654f
C9875 DVDD.n586 DGND 3.59e-19
C9876 DVDD.n587 DGND 0.002828f
C9877 DVDD.n588 DGND 9.56e-19
C9878 DVDD.t750 DGND 0.004371f
C9879 DVDD.t390 DGND 4.69e-19
C9880 DVDD.t828 DGND 4.69e-19
C9881 DVDD.n589 DGND 9.6e-19
C9882 DVDD.t399 DGND 0.00437f
C9883 DVDD.n590 DGND 0.005118f
C9884 DVDD.n591 DGND 0.002563f
C9885 DVDD.n592 DGND 0.005579f
C9886 DVDD.n593 DGND 6.54e-19
C9887 DVDD.n594 DGND 0.003654f
C9888 DVDD.n595 DGND 0.003654f
C9889 DVDD.n596 DGND 0.003654f
C9890 DVDD.n597 DGND 0.001104f
C9891 DVDD.n598 DGND 0.006816f
C9892 DVDD.t832 DGND 0.002373f
C9893 DVDD.n599 DGND 0.002746f
C9894 DVDD.n600 DGND 7.88e-19
C9895 DVDD.n601 DGND 0.003654f
C9896 DVDD.n602 DGND 0.003654f
C9897 DVDD.n603 DGND 7.88e-19
C9898 DVDD.n604 DGND 9.21e-19
C9899 DVDD.n605 DGND 0.00396f
C9900 DVDD.n606 DGND 0.003654f
C9901 DVDD.n607 DGND 0.003654f
C9902 DVDD.n608 DGND 0.003654f
C9903 DVDD.n609 DGND 8.65e-19
C9904 DVDD.n610 DGND 0.00369f
C9905 DVDD.t153 DGND 0.001701f
C9906 DVDD.t629 DGND 4.69e-19
C9907 DVDD.t139 DGND 4.69e-19
C9908 DVDD.n611 DGND 9.6e-19
C9909 DVDD.n612 DGND 0.002253f
C9910 DVDD.n613 DGND 0.002631f
C9911 DVDD.n614 DGND 9.49e-19
C9912 DVDD.n615 DGND 0.003654f
C9913 DVDD.n616 DGND 0.003654f
C9914 DVDD.n617 DGND 0.003654f
C9915 DVDD.n618 DGND 9.85e-19
C9916 DVDD.n619 DGND 0.002547f
C9917 DVDD.n620 DGND 0.002253f
C9918 DVDD.n621 DGND 9.28e-19
C9919 DVDD.t7 DGND 4.69e-19
C9920 DVDD.t625 DGND 4.69e-19
C9921 DVDD.n622 DGND 9.72e-19
C9922 DVDD.n623 DGND 0.003043f
C9923 DVDD.n624 DGND 7.81e-19
C9924 DVDD.n625 DGND 0.003654f
C9925 DVDD.n626 DGND 0.003654f
C9926 DVDD.n627 DGND 0.003654f
C9927 DVDD.n628 DGND 8.16e-19
C9928 DVDD.n629 DGND 0.003223f
C9929 DVDD.n630 DGND 5.7e-19
C9930 DVDD.n631 DGND 0.005934f
C9931 DVDD.n632 DGND 0.003654f
C9932 DVDD.n633 DGND 0.003654f
C9933 DVDD.n634 DGND 5.84e-19
C9934 DVDD.n635 DGND 0.006816f
C9935 DVDD.t92 DGND 0.002359f
C9936 DVDD.t368 DGND 0.00437f
C9937 DVDD.n636 DGND 0.004977f
C9938 DVDD.n637 DGND 0.002839f
C9939 DVDD.n638 DGND 9.49e-19
C9940 DVDD.n639 DGND 0.003654f
C9941 DVDD.n640 DGND 0.003654f
C9942 DVDD.n641 DGND 0.003654f
C9943 DVDD.n642 DGND 0.001104f
C9944 DVDD.n643 DGND 0.006816f
C9945 DVDD.n644 DGND 7.67e-19
C9946 DVDD.n645 DGND 0.005302f
C9947 DVDD.n646 DGND 5.41e-19
C9948 DVDD.n647 DGND 0.003654f
C9949 DVDD.n648 DGND 0.003654f
C9950 DVDD.n649 DGND 0.003654f
C9951 DVDD.t128 DGND 0.00237f
C9952 DVDD.n650 DGND 0.003383f
C9953 DVDD.t47 DGND 0.001713f
C9954 DVDD.n651 DGND 0.003189f
C9955 DVDD.n652 DGND 7.24e-19
C9956 DVDD.t49 DGND 4.69e-19
C9957 DVDD.t90 DGND 4.69e-19
C9958 DVDD.n653 DGND 9.72e-19
C9959 DVDD.n654 DGND 0.003043f
C9960 DVDD.n655 DGND 7.81e-19
C9961 DVDD.n656 DGND 0.003654f
C9962 DVDD.n657 DGND 0.003654f
C9963 DVDD.n658 DGND 0.003654f
C9964 DVDD.n659 DGND 8.65e-19
C9965 DVDD.t130 DGND 4.69e-19
C9966 DVDD.t433 DGND 4.69e-19
C9967 DVDD.n660 DGND 9.72e-19
C9968 DVDD.n661 DGND 0.00369f
C9969 DVDD.n662 DGND 7.17e-19
C9970 DVDD.n663 DGND 0.003654f
C9971 DVDD.n664 DGND 0.003654f
C9972 DVDD.n665 DGND 7.24e-19
C9973 DVDD.n666 DGND 0.001013f
C9974 DVDD.n667 DGND 0.00245f
C9975 DVDD.n668 DGND 0.002495f
C9976 DVDD.n669 DGND 7.88e-19
C9977 DVDD.n670 DGND 0.003654f
C9978 DVDD.n671 DGND 0.003654f
C9979 DVDD.n672 DGND 0.003654f
C9980 DVDD.n673 DGND 0.001294f
C9981 DVDD.n674 DGND 8.16e-19
C9982 DVDD.t132 DGND 0.002388f
C9983 DVDD.n675 DGND 0.003223f
C9984 DVDD.t905 DGND 4.69e-19
C9985 DVDD.t748 DGND 4.69e-19
C9986 DVDD.n676 DGND 9.6e-19
C9987 DVDD.n677 DGND 0.00257f
C9988 DVDD.n678 DGND 5.77e-19
C9989 DVDD.n679 DGND 0.003654f
C9990 DVDD.n680 DGND 0.003654f
C9991 DVDD.n681 DGND 6.68e-19
C9992 DVDD.n682 DGND 9.85e-19
C9993 DVDD.n683 DGND 0.002828f
C9994 DVDD.t332 DGND 0.004371f
C9995 DVDD.n684 DGND 0.005839f
C9996 DVDD.n685 DGND 3.16e-19
C9997 DVDD.n686 DGND 0.003654f
C9998 DVDD.n687 DGND 0.003654f
C9999 DVDD.n688 DGND 3.87e-19
C10000 DVDD.n689 DGND 0.002591f
C10001 DVDD.n690 DGND 7.38e-19
C10002 DVDD.t194 DGND 0.004456f
C10003 DVDD.n691 DGND 0.006612f
C10004 DVDD.n692 DGND 0.003654f
C10005 DVDD.n693 DGND 0.003654f
C10006 DVDD.n694 DGND 0.003654f
C10007 DVDD.n695 DGND 8.3e-19
C10008 DVDD.n696 DGND 0.002886f
C10009 DVDD.n697 DGND 3.09e-19
C10010 DVDD.n698 DGND 0.005656f
C10011 DVDD.t716 DGND 0.004455f
C10012 DVDD.t253 DGND 0.004455f
C10013 DVDD.n699 DGND 0.011157f
C10014 DVDD.n700 DGND 0.003654f
C10015 DVDD.n701 DGND 0.003654f
C10016 DVDD.n702 DGND 0.003654f
C10017 DVDD.t169 DGND 0.004456f
C10018 DVDD.n703 DGND 0.01174f
C10019 DVDD.t754 DGND 0.004455f
C10020 DVDD.n704 DGND 0.006208f
C10021 DVDD.t913 DGND 0.004368f
C10022 DVDD.n705 DGND 0.004543f
C10023 DVDD.n706 DGND 8.3e-19
C10024 DVDD.n707 DGND 0.006665f
C10025 DVDD.n708 DGND 0.001827f
C10026 DVDD.n709 DGND 0.043207f
C10027 DVDD.n710 DGND 0.002422f
C10028 DVDD.n711 DGND 6.96e-19
C10029 DVDD.n712 DGND 0.003654f
C10030 DVDD.n713 DGND 8.44e-19
C10031 DVDD.n714 DGND 0.003654f
C10032 DVDD.t58 DGND 4.69e-19
C10033 DVDD.t807 DGND 4.69e-19
C10034 DVDD.n715 DGND 9.72e-19
C10035 DVDD.n716 DGND 0.003599f
C10036 DVDD.n717 DGND 0.003654f
C10037 DVDD.t218 DGND 0.002388f
C10038 DVDD.n718 DGND 0.003223f
C10039 DVDD.n719 DGND 0.003654f
C10040 DVDD.n720 DGND 6.96e-19
C10041 DVDD.n721 DGND 0.003654f
C10042 DVDD.t216 DGND 4.69e-19
C10043 DVDD.t456 DGND 4.69e-19
C10044 DVDD.n722 DGND 9.72e-19
C10045 DVDD.n723 DGND 0.00369f
C10046 DVDD.n724 DGND 0.003654f
C10047 DVDD.t363 DGND 0.001713f
C10048 DVDD.n725 DGND 0.00328f
C10049 DVDD.n726 DGND 0.003654f
C10050 DVDD.t208 DGND 0.002359f
C10051 DVDD.t355 DGND 4.69e-19
C10052 DVDD.t780 DGND 4.69e-19
C10053 DVDD.n727 DGND 9.6e-19
C10054 DVDD.n728 DGND 9.7e-19
C10055 DVDD.n729 DGND 0.003654f
C10056 DVDD.n730 DGND 8.02e-19
C10057 DVDD.t287 DGND 0.074222f
C10058 DVDD.t570 DGND 0.060056f
C10059 DVDD.t882 DGND 0.049754f
C10060 DVDD.t262 DGND 0.031843f
C10061 DVDD.t857 DGND 0.019667f
C10062 DVDD.t861 DGND 0.019667f
C10063 DVDD.t261 DGND 0.032545f
C10064 DVDD.n731 DGND 9.7e-19
C10065 DVDD.n732 DGND 9.21e-19
C10066 DVDD.n733 DGND 0.003654f
C10067 DVDD.t798 DGND 0.001852f
C10068 DVDD.t949 DGND 0.001157f
C10069 DVDD.n734 DGND 0.012237f
C10070 DVDD.t858 DGND 0.001117f
C10071 DVDD.t862 DGND 0.001117f
C10072 DVDD.n735 DGND 0.002423f
C10073 DVDD.n736 DGND 0.001167f
C10074 DVDD.n737 DGND 0.012629f
C10075 DVDD.n738 DGND 0.001294f
C10076 DVDD.t288 DGND 0.004647f
C10077 DVDD.n739 DGND 0.016803f
C10078 DVDD.t571 DGND 0.00445f
C10079 DVDD.n740 DGND 0.005196f
C10080 DVDD.n741 DGND 8.02e-19
C10081 DVDD.n742 DGND 0.014314f
C10082 DVDD.n743 DGND 0.003654f
C10083 DVDD.n744 DGND 0.002025f
C10084 DVDD.n745 DGND 0.001294f
C10085 DVDD.t263 DGND 0.003921f
C10086 DVDD.n746 DGND 0.002463f
C10087 DVDD.n747 DGND 7.74e-19
C10088 DVDD.n748 DGND 0.003455f
C10089 DVDD.n749 DGND 0.003654f
C10090 DVDD.n750 DGND 0.003654f
C10091 DVDD.n751 DGND 6.61e-19
C10092 DVDD.n752 DGND 0.002849f
C10093 DVDD.n753 DGND 9.56e-19
C10094 DVDD.n754 DGND 0.030683f
C10095 DVDD.n755 DGND 9.7e-19
C10096 DVDD.n756 DGND 0.003654f
C10097 DVDD.n757 DGND 0.003654f
C10098 DVDD.n758 DGND 0.003654f
C10099 DVDD.t425 DGND 5.04e-19
C10100 DVDD.t42 DGND 6.43e-19
C10101 DVDD.n759 DGND 0.001239f
C10102 DVDD.n760 DGND 0.001294f
C10103 DVDD.n761 DGND 0.003654f
C10104 DVDD.t222 DGND 0.001701f
C10105 DVDD.n762 DGND 0.002828f
C10106 DVDD.n763 DGND 0.003654f
C10107 DVDD.t423 DGND 9.16e-19
C10108 DVDD.t633 DGND 2.97e-19
C10109 DVDD.n764 DGND 0.004416f
C10110 DVDD.t651 DGND 0.00237f
C10111 DVDD.n765 DGND 0.00396f
C10112 DVDD.n766 DGND 0.003654f
C10113 DVDD.n767 DGND 8.65e-19
C10114 DVDD.n768 DGND 0.003654f
C10115 DVDD.n769 DGND 7.81e-19
C10116 DVDD.n770 DGND 0.003654f
C10117 DVDD.t11 DGND 4.69e-19
C10118 DVDD.t657 DGND 4.69e-19
C10119 DVDD.n771 DGND 9.72e-19
C10120 DVDD.t259 DGND 0.004421f
C10121 DVDD.n772 DGND 0.006885f
C10122 DVDD.t971 DGND 0.001067f
C10123 DVDD.t801 DGND 0.001477f
C10124 DVDD.n773 DGND 0.006432f
C10125 DVDD.t951 DGND 0.001573f
C10126 DVDD.t784 DGND 9.84e-19
C10127 DVDD.n774 DGND 0.00305f
C10128 DVDD.n775 DGND 0.011169f
C10129 DVDD.t962 DGND 0.00166f
C10130 DVDD.t825 DGND 8.91e-19
C10131 DVDD.n776 DGND 0.003043f
C10132 DVDD.n777 DGND 0.017929f
C10133 DVDD.n778 DGND 8.16e-19
C10134 DVDD.n779 DGND 0.003654f
C10135 DVDD.t655 DGND 0.002388f
C10136 DVDD.t958 DGND 0.001067f
C10137 DVDD.t768 DGND 0.001477f
C10138 DVDD.n780 DGND 0.006432f
C10139 DVDD.t953 DGND 0.001573f
C10140 DVDD.t778 DGND 9.84e-19
C10141 DVDD.n781 DGND 0.00305f
C10142 DVDD.n782 DGND 0.011169f
C10143 DVDD.t945 DGND 0.00166f
C10144 DVDD.t794 DGND 8.91e-19
C10145 DVDD.n783 DGND 0.003043f
C10146 DVDD.n784 DGND 0.01394f
C10147 DVDD.n785 DGND 0.009463f
C10148 DVDD.t112 DGND 0.00445f
C10149 DVDD.n786 DGND 0.004665f
C10150 DVDD.t353 DGND 0.00237f
C10151 DVDD.n787 DGND 0.003654f
C10152 DVDD.n788 DGND 0.00351f
C10153 DVDD.n789 DGND 9.21e-19
C10154 DVDD.n790 DGND 7.74e-19
C10155 DVDD.n791 DGND 0.003654f
C10156 DVDD.n792 DGND 0.003654f
C10157 DVDD.n793 DGND 0.003654f
C10158 DVDD.n794 DGND 9.7e-19
C10159 DVDD.n795 DGND 0.006941f
C10160 DVDD.n796 DGND 9.7e-19
C10161 DVDD.n797 DGND 6.96e-19
C10162 DVDD.n798 DGND 0.003654f
C10163 DVDD.n799 DGND 0.003654f
C10164 DVDD.n800 DGND 0.003654f
C10165 DVDD.n801 DGND 7.24e-19
C10166 DVDD.t14 DGND 0.001713f
C10167 DVDD.n802 DGND 0.00328f
C10168 DVDD.n803 DGND 2.6e-19
C10169 DVDD.t860 DGND 0.00445f
C10170 DVDD.n804 DGND 0.004721f
C10171 DVDD.t653 DGND 4.69e-19
C10172 DVDD.t786 DGND 4.69e-19
C10173 DVDD.n805 DGND 9.72e-19
C10174 DVDD.n806 DGND 0.00324f
C10175 DVDD.n807 DGND 0.003654f
C10176 DVDD.n808 DGND 0.003654f
C10177 DVDD.n809 DGND 0.003654f
C10178 DVDD.n810 DGND 7.74e-19
C10179 DVDD.t931 DGND 0.002388f
C10180 DVDD.n811 DGND 0.003223f
C10181 DVDD.n812 DGND 8.16e-19
C10182 DVDD.n813 DGND 0.001203f
C10183 DVDD.n814 DGND 0.003654f
C10184 DVDD.n815 DGND 0.003654f
C10185 DVDD.n816 DGND 0.003654f
C10186 DVDD.n817 DGND 3.23e-19
C10187 DVDD.t224 DGND 4.69e-19
C10188 DVDD.t935 DGND 4.69e-19
C10189 DVDD.n818 DGND 9.72e-19
C10190 DVDD.n819 DGND 0.003043f
C10191 DVDD.n820 DGND 7.67e-19
C10192 DVDD.n821 DGND 0.003465f
C10193 DVDD.n822 DGND 3.23e-19
C10194 DVDD.n823 DGND 0.003654f
C10195 DVDD.n824 DGND 0.003654f
C10196 DVDD.n825 DGND 9.49e-19
C10197 DVDD.t937 DGND 4.69e-19
C10198 DVDD.t286 DGND 4.69e-19
C10199 DVDD.n826 DGND 9.72e-19
C10200 DVDD.n827 DGND 0.00369f
C10201 DVDD.n828 DGND 8.65e-19
C10202 DVDD.n829 DGND 0.003654f
C10203 DVDD.n830 DGND 0.003654f
C10204 DVDD.n831 DGND 0.003654f
C10205 DVDD.n832 DGND 9.7e-19
C10206 DVDD.n833 DGND 0.002692f
C10207 DVDD.n834 DGND 8.79e-19
C10208 DVDD.t933 DGND 0.00237f
C10209 DVDD.n835 DGND 0.00396f
C10210 DVDD.n836 DGND 0.003654f
C10211 DVDD.n837 DGND 0.003654f
C10212 DVDD.n838 DGND 0.003654f
C10213 DVDD.n839 DGND 9.7e-19
C10214 DVDD.n840 DGND 0.009957f
C10215 DVDD.n841 DGND 0.061183f
C10216 DVDD.t932 DGND 0.03793f
C10217 DVDD.t424 DGND 0.011239f
C10218 DVDD.t220 DGND 0.011239f
C10219 DVDD.t41 DGND 0.008429f
C10220 DVDD.t289 DGND 0.008429f
C10221 DVDD.t275 DGND 0.011239f
C10222 DVDD.t458 DGND 0.014985f
C10223 DVDD.t936 DGND 0.020253f
C10224 DVDD.t285 DGND 0.010068f
C10225 DVDD.t149 DGND 0.009834f
C10226 DVDD.t221 DGND 0.012058f
C10227 DVDD.t422 DGND 0.015219f
C10228 DVDD.t632 DGND 0.019551f
C10229 DVDD.t223 DGND 0.016624f
C10230 DVDD.t934 DGND 0.019667f
C10231 DVDD.t283 DGND 0.014868f
C10232 DVDD.t650 DGND 0.009834f
C10233 DVDD.t219 DGND 0.011239f
C10234 DVDD.t12 DGND 0.010536f
C10235 DVDD.t930 DGND 0.008429f
C10236 DVDD.t826 DGND 0.01557f
C10237 DVDD.t260 DGND 0.021658f
C10238 DVDD.t652 DGND 0.018965f
C10239 DVDD.t859 DGND 0.009834f
C10240 DVDD.t785 DGND 0.011122f
C10241 DVDD.t13 DGND 0.031023f
C10242 DVDD.t258 DGND 0.022009f
C10243 DVDD.t10 DGND 0.010653f
C10244 DVDD.t656 DGND 0.019667f
C10245 DVDD.t802 DGND 0.019667f
C10246 DVDD.t15 DGND 0.02037f
C10247 DVDD.t654 DGND 0.045072f
C10248 DVDD.t111 DGND 0.038516f
C10249 DVDD.t352 DGND 0.015219f
C10250 DVDD.t359 DGND 0.019667f
C10251 DVDD.t795 DGND 0.011356f
C10252 DVDD.t340 DGND 0.0535f
C10253 DVDD.t757 DGND 0.010536f
C10254 DVDD.t181 DGND 0.011824f
C10255 DVDD.t337 DGND 0.019667f
C10256 DVDD.t346 DGND 0.019667f
C10257 DVDD.t184 DGND 0.012878f
C10258 DVDD.t51 DGND 0.01358f
C10259 DVDD.t308 DGND 0.018965f
C10260 DVDD.t182 DGND 0.009834f
C10261 DVDD.t771 DGND 0.009834f
C10262 DVDD.t335 DGND 0.009834f
C10263 DVDD.t53 DGND 0.009834f
C10264 DVDD.t344 DGND 0.009834f
C10265 DVDD.t306 DGND 0.010419f
C10266 DVDD.t276 DGND 0.020253f
C10267 DVDD.t338 DGND 0.012995f
C10268 DVDD.t311 DGND 0.008429f
C10269 DVDD.t180 DGND 0.009834f
C10270 DVDD.t806 DGND 0.011239f
C10271 DVDD.t342 DGND 0.009834f
C10272 DVDD.t57 DGND 0.012175f
C10273 DVDD.t428 DGND 0.021658f
C10274 DVDD.t818 DGND 0.019667f
C10275 DVDD.t309 DGND 0.015102f
C10276 DVDD.t217 DGND 0.011239f
C10277 DVDD.t55 DGND 0.010536f
C10278 DVDD.t608 DGND 0.015804f
C10279 DVDD.t454 DGND 0.019667f
C10280 DVDD.t211 DGND 0.019667f
C10281 DVDD.t605 DGND 0.023648f
C10282 DVDD.t348 DGND 0.022009f
C10283 DVDD.t600 DGND 0.010536f
C10284 DVDD.t361 DGND 0.009834f
C10285 DVDD.t455 DGND 0.009834f
C10286 DVDD.t769 DGND 0.009834f
C10287 DVDD.t215 DGND 0.009834f
C10288 DVDD.t350 DGND 0.010419f
C10289 DVDD.t339 DGND 0.009834f
C10290 DVDD.t357 DGND 0.011239f
C10291 DVDD.t457 DGND 0.017912f
C10292 DVDD.t599 DGND 0.012526f
C10293 DVDD.t362 DGND 0.011239f
C10294 DVDD.t207 DGND 0.009834f
C10295 DVDD.t779 DGND 0.012526f
C10296 DVDD.t354 DGND 0.020253f
C10297 DVDD.t726 DGND 0.018731f
C10298 DVDD.n842 DGND 0.014846f
C10299 DVDD.n843 DGND 0.005302f
C10300 DVDD.n844 DGND 9.7e-19
C10301 DVDD.n845 DGND 0.003654f
C10302 DVDD.n846 DGND 0.003654f
C10303 DVDD.n847 DGND 0.003654f
C10304 DVDD.n848 DGND 0.001097f
C10305 DVDD.n849 DGND 0.00245f
C10306 DVDD.n850 DGND 0.00241f
C10307 DVDD.n851 DGND 7.88e-19
C10308 DVDD.n852 DGND 7.52e-19
C10309 DVDD.n853 DGND 0.003654f
C10310 DVDD.n854 DGND 0.003654f
C10311 DVDD.n855 DGND 7.24e-19
C10312 DVDD.n856 DGND 7.81e-19
C10313 DVDD.t358 DGND 4.69e-19
C10314 DVDD.t351 DGND 4.69e-19
C10315 DVDD.n857 DGND 9.72e-19
C10316 DVDD.n858 DGND 0.003043f
C10317 DVDD.n859 DGND 2.67e-19
C10318 DVDD.n860 DGND 0.003654f
C10319 DVDD.n861 DGND 0.003654f
C10320 DVDD.n862 DGND 0.003654f
C10321 DVDD.n863 DGND 7.17e-19
C10322 DVDD.t601 DGND 0.001713f
C10323 DVDD.n864 DGND 0.00328f
C10324 DVDD.n865 DGND 2.46e-19
C10325 DVDD.t349 DGND 0.002388f
C10326 DVDD.n866 DGND 0.003223f
C10327 DVDD.t606 DGND 4.69e-19
C10328 DVDD.t212 DGND 4.69e-19
C10329 DVDD.n867 DGND 9.72e-19
C10330 DVDD.n868 DGND 0.003043f
C10331 DVDD.n869 DGND 2.6e-19
C10332 DVDD.n870 DGND 0.003654f
C10333 DVDD.n871 DGND 0.003654f
C10334 DVDD.n872 DGND 0.003654f
C10335 DVDD.n873 DGND 9.21e-19
C10336 DVDD.t56 DGND 0.00237f
C10337 DVDD.n874 DGND 0.00396f
C10338 DVDD.n875 DGND 7.24e-19
C10339 DVDD.n876 DGND 0.003654f
C10340 DVDD.n877 DGND 0.003654f
C10341 DVDD.n878 DGND 7.74e-19
C10342 DVDD.n879 DGND 9.21e-19
C10343 DVDD.t343 DGND 0.00237f
C10344 DVDD.n880 DGND 0.003531f
C10345 DVDD.n881 DGND 0.003654f
C10346 DVDD.n882 DGND 0.003654f
C10347 DVDD.n883 DGND 0.003654f
C10348 DVDD.n884 DGND 7.17e-19
C10349 DVDD.t312 DGND 0.001713f
C10350 DVDD.n885 DGND 0.00328f
C10351 DVDD.n886 DGND 7.24e-19
C10352 DVDD.t307 DGND 4.69e-19
C10353 DVDD.t54 DGND 4.69e-19
C10354 DVDD.n887 DGND 9.6e-19
C10355 DVDD.t345 DGND 4.69e-19
C10356 DVDD.t336 DGND 4.69e-19
C10357 DVDD.n888 DGND 9.6e-19
C10358 DVDD.n889 DGND 0.002225f
C10359 DVDD.n890 DGND 0.002394f
C10360 DVDD.n891 DGND 0.001013f
C10361 DVDD.n892 DGND 0.003654f
C10362 DVDD.n893 DGND 0.003654f
C10363 DVDD.n894 DGND 0.003654f
C10364 DVDD.n895 DGND 7.52e-19
C10365 DVDD.t183 DGND 0.001713f
C10366 DVDD.n896 DGND 0.00328f
C10367 DVDD.n897 DGND 7.24e-19
C10368 DVDD.t52 DGND 0.002385f
C10369 DVDD.t185 DGND 4.69e-19
C10370 DVDD.t347 DGND 4.69e-19
C10371 DVDD.n898 DGND 9.72e-19
C10372 DVDD.n899 DGND 0.005271f
C10373 DVDD.n900 DGND 7.81e-19
C10374 DVDD.n901 DGND 0.003654f
C10375 DVDD.n902 DGND 0.003654f
C10376 DVDD.n903 DGND 0.003654f
C10377 DVDD.n904 DGND 0.001294f
C10378 DVDD.n905 DGND 8.44e-19
C10379 DVDD.t758 DGND 0.00445f
C10380 DVDD.n906 DGND 0.00483f
C10381 DVDD.t341 DGND 0.00241f
C10382 DVDD.n907 DGND 0.004055f
C10383 DVDD.n908 DGND 0.019509f
C10384 DVDD.n909 DGND 0.002422f
C10385 DVDD.t705 DGND 0.001117f
C10386 DVDD.t707 DGND 0.001117f
C10387 DVDD.n910 DGND 0.002423f
C10388 DVDD.t427 DGND 0.003921f
C10389 DVDD.n911 DGND 0.002463f
C10390 DVDD.n912 DGND 0.003654f
C10391 DVDD.t506 DGND 0.001713f
C10392 DVDD.n913 DGND 0.00328f
C10393 DVDD.n914 DGND 0.003654f
C10394 DVDD.n915 DGND 0.001294f
C10395 DVDD.n916 DGND 0.003654f
C10396 DVDD.t585 DGND 0.002359f
C10397 DVDD.n917 DGND 0.002523f
C10398 DVDD.n918 DGND 0.003654f
C10399 DVDD.n919 DGND 9.42e-19
C10400 DVDD.t255 DGND 0.004456f
C10401 DVDD.n920 DGND 0.003654f
C10402 DVDD.t134 DGND 0.004455f
C10403 DVDD.n921 DGND 0.006039f
C10404 DVDD.n922 DGND 0.003654f
C10405 DVDD.t561 DGND 0.001117f
C10406 DVDD.t559 DGND 0.001117f
C10407 DVDD.n923 DGND 0.002423f
C10408 DVDD.n924 DGND 0.001167f
C10409 DVDD.n925 DGND 0.003654f
C10410 DVDD.t940 DGND 0.001713f
C10411 DVDD.n926 DGND 0.00328f
C10412 DVDD.n927 DGND 0.003654f
C10413 DVDD.t649 DGND 4.69e-19
C10414 DVDD.t461 DGND 4.69e-19
C10415 DVDD.n928 DGND 9.6e-19
C10416 DVDD.t429 DGND 0.038867f
C10417 DVDD.t590 DGND 0.009834f
C10418 DVDD.t706 DGND 0.010536f
C10419 DVDD.t509 DGND 0.009834f
C10420 DVDD.t704 DGND 0.009834f
C10421 DVDD.t84 DGND 0.009834f
C10422 DVDD.t426 DGND 0.009834f
C10423 DVDD.t588 DGND 0.016624f
C10424 DVDD.t507 DGND 0.015219f
C10425 DVDD.t863 DGND 0.022009f
C10426 DVDD.t505 DGND 0.026458f
C10427 DVDD.t38 DGND 0.013346f
C10428 DVDD.t530 DGND 0.009834f
C10429 DVDD.t586 DGND 0.010536f
C10430 DVDD.t582 DGND 0.010419f
C10431 DVDD.t708 DGND 0.009834f
C10432 DVDD.t623 DGND 0.011239f
C10433 DVDD.t622 DGND 0.009834f
C10434 DVDD.t532 DGND 0.008429f
C10435 DVDD.t510 DGND 0.009834f
C10436 DVDD.t580 DGND 0.011239f
C10437 DVDD.t584 DGND 0.022009f
C10438 DVDD.t577 DGND 0.024233f
C10439 DVDD.t611 DGND 0.019667f
C10440 DVDD.t528 DGND 0.018497f
C10441 DVDD.t254 DGND 0.010419f
C10442 DVDD.t310 DGND 0.009834f
C10443 DVDD.t755 DGND 0.011239f
C10444 DVDD.t484 DGND 0.01159f
C10445 DVDD.t583 DGND 0.019316f
C10446 DVDD.t281 DGND 0.011239f
C10447 DVDD.t526 DGND 0.009834f
C10448 DVDD.t133 DGND 0.032428f
C10449 DVDD.t316 DGND 0.029033f
C10450 DVDD.t642 DGND 0.009834f
C10451 DVDD.t558 DGND 0.010536f
C10452 DVDD.t938 DGND 0.009834f
C10453 DVDD.t560 DGND 0.009834f
C10454 DVDD.t459 DGND 0.009834f
C10455 DVDD.t313 DGND 0.009834f
C10456 DVDD.t644 DGND 0.016624f
C10457 DVDD.t941 DGND 0.015219f
C10458 DVDD.t305 DGND 0.022009f
C10459 DVDD.t939 DGND 0.026458f
C10460 DVDD.t460 DGND 0.016858f
C10461 DVDD.n929 DGND 0.013441f
C10462 DVDD.n930 DGND 7.74e-19
C10463 DVDD.n931 DGND 0.003654f
C10464 DVDD.t647 DGND 0.00237f
C10465 DVDD.n932 DGND 0.003654f
C10466 DVDD.t240 DGND 4.69e-19
C10467 DVDD.t439 DGND 4.69e-19
C10468 DVDD.n933 DGND 9.72e-19
C10469 DVDD.n934 DGND 0.003043f
C10470 DVDD.n935 DGND 0.003654f
C10471 DVDD.t244 DGND 0.001713f
C10472 DVDD.t435 DGND 4.69e-19
C10473 DVDD.t621 DGND 4.69e-19
C10474 DVDD.n936 DGND 9.72e-19
C10475 DVDD.n937 DGND 0.00369f
C10476 DVDD.n938 DGND 0.003654f
C10477 DVDD.t964 DGND 0.001067f
C10478 DVDD.t812 DGND 0.001477f
C10479 DVDD.n939 DGND 0.006432f
C10480 DVDD.t960 DGND 0.001573f
C10481 DVDD.t822 DGND 9.84e-19
C10482 DVDD.n940 DGND 0.00305f
C10483 DVDD.n941 DGND 0.011169f
C10484 DVDD.t970 DGND 0.00166f
C10485 DVDD.t796 DGND 8.91e-19
C10486 DVDD.n942 DGND 0.003043f
C10487 DVDD.n943 DGND 0.021149f
C10488 DVDD.n944 DGND 7.74e-19
C10489 DVDD.n945 DGND 0.003654f
C10490 DVDD.t915 DGND 0.002388f
C10491 DVDD.n946 DGND 0.003131f
C10492 DVDD.t441 DGND 0.00237f
C10493 DVDD.t800 DGND 0.00437f
C10494 DVDD.n947 DGND 0.005483f
C10495 DVDD.n948 DGND 0.003654f
C10496 DVDD.t850 DGND 4.69e-19
C10497 DVDD.t921 DGND 4.69e-19
C10498 DVDD.n949 DGND 9.6e-19
C10499 DVDD.t117 DGND 0.001117f
C10500 DVDD.t414 DGND 0.001117f
C10501 DVDD.n950 DGND 0.002398f
C10502 DVDD.t848 DGND 0.001713f
C10503 DVDD.n951 DGND 0.00328f
C10504 DVDD.n952 DGND 0.003654f
C10505 DVDD.t161 DGND 0.004816f
C10506 DVDD.t919 DGND 4.69e-19
C10507 DVDD.t158 DGND 4.69e-19
C10508 DVDD.n953 DGND 9.6e-19
C10509 DVDD.n954 DGND 0.00128f
C10510 DVDD.n955 DGND 0.003654f
C10511 DVDD.t604 DGND 0.003921f
C10512 DVDD.t917 DGND 0.002359f
C10513 DVDD.n956 DGND 0.00286f
C10514 DVDD.n957 DGND 0.003654f
C10515 DVDD.t868 DGND 0.06111f
C10516 DVDD.t892 DGND 0.019667f
C10517 DVDD.t412 DGND 0.017092f
C10518 DVDD.t174 DGND 0.011239f
C10519 DVDD.t284 DGND 0.012995f
C10520 DVDD.t866 DGND 0.020253f
C10521 DVDD.t409 DGND 0.014751f
C10522 DVDD.t304 DGND 0.009834f
C10523 DVDD.t893 DGND 0.022009f
C10524 DVDD.t30 DGND 0.022009f
C10525 DVDD.t896 DGND 0.009834f
C10526 DVDD.t178 DGND 0.009834f
C10527 DVDD.t864 DGND 0.009834f
C10528 DVDD.t176 DGND 0.009834f
C10529 DVDD.t408 DGND 0.009834f
C10530 DVDD.t27 DGND 0.009834f
C10531 DVDD.t895 DGND 0.015453f
C10532 DVDD.t870 DGND 0.017794f
C10533 DVDD.t648 DGND 0.013229f
C10534 DVDD.t241 DGND 0.021658f
C10535 DVDD.t462 DGND 0.01557f
C10536 DVDD.t436 DGND 0.008429f
C10537 DVDD.t943 DGND 0.010536f
C10538 DVDD.t242 DGND 0.011239f
C10539 DVDD.t646 DGND 0.009834f
C10540 DVDD.t85 DGND 0.014868f
C10541 DVDD.t438 DGND 0.019667f
C10542 DVDD.t239 DGND 0.031843f
C10543 DVDD.t243 DGND 0.031843f
C10544 DVDD.t620 DGND 0.019667f
C10545 DVDD.t434 DGND 0.020253f
C10546 DVDD.t360 DGND 0.021658f
C10547 DVDD.t40 DGND 0.019667f
C10548 DVDD.t238 DGND 0.019667f
C10549 DVDD.t440 DGND 0.017443f
C10550 DVDD.t914 DGND 0.016741f
C10551 DVDD.t852 DGND 0.02037f
C10552 DVDD.t156 DGND 0.019667f
C10553 DVDD.t920 DGND 0.015687f
C10554 DVDD.t799 DGND 0.009834f
C10555 DVDD.t849 DGND 0.009834f
C10556 DVDD.t413 DGND 0.015687f
C10557 DVDD.t116 DGND 0.016155f
C10558 DVDD.t847 DGND 0.011239f
C10559 DVDD.t160 DGND 0.009834f
C10560 DVDD.t157 DGND 0.014751f
C10561 DVDD.t918 DGND 0.018965f
C10562 DVDD.t607 DGND 0.010419f
C10563 DVDD.t602 DGND 0.009834f
C10564 DVDD.t213 DGND 0.011239f
C10565 DVDD.t159 DGND 0.009834f
C10566 DVDD.t209 DGND 0.008429f
C10567 DVDD.t851 DGND 0.009834f
C10568 DVDD.t603 DGND 0.011239f
C10569 DVDD.t916 DGND 0.022009f
C10570 DVDD.t356 DGND 0.042028f
C10571 DVDD.n958 DGND 0.033668f
C10572 DVDD.t871 DGND 0.002388f
C10573 DVDD.n959 DGND 0.007787f
C10574 DVDD.n960 DGND 0.003654f
C10575 DVDD.t179 DGND 0.001117f
C10576 DVDD.t177 DGND 0.001117f
C10577 DVDD.n961 DGND 0.002423f
C10578 DVDD.n962 DGND 0.002849f
C10579 DVDD.n963 DGND 0.003654f
C10580 DVDD.t897 DGND 4.69e-19
C10581 DVDD.t865 DGND 4.69e-19
C10582 DVDD.n964 DGND 9.6e-19
C10583 DVDD.t31 DGND 0.003921f
C10584 DVDD.t894 DGND 0.001713f
C10585 DVDD.n965 DGND 0.00328f
C10586 DVDD.n966 DGND 0.003654f
C10587 DVDD.t175 DGND 0.00445f
C10588 DVDD.n967 DGND 0.005216f
C10589 DVDD.t869 DGND 0.002415f
C10590 DVDD.n968 DGND 0.020973f
C10591 DVDD.n969 DGND 0.008666f
C10592 DVDD.n970 DGND 3.73e-19
C10593 DVDD.t867 DGND 4.69e-19
C10594 DVDD.t410 DGND 4.69e-19
C10595 DVDD.n971 DGND 9.72e-19
C10596 DVDD.n972 DGND 0.00369f
C10597 DVDD.n973 DGND 7.17e-19
C10598 DVDD.n974 DGND 0.002025f
C10599 DVDD.n975 DGND 0.001827f
C10600 DVDD.n976 DGND 0.003455f
C10601 DVDD.n977 DGND 2.04e-19
C10602 DVDD.n978 DGND 0.002463f
C10603 DVDD.n979 DGND 8.86e-19
C10604 DVDD.n980 DGND 0.002591f
C10605 DVDD.n981 DGND 2.95e-19
C10606 DVDD.n982 DGND 0.003654f
C10607 DVDD.n983 DGND 0.003654f
C10608 DVDD.n984 DGND 0.00128f
C10609 DVDD.n985 DGND 0.001294f
C10610 DVDD.n986 DGND 8.16e-19
C10611 DVDD.n987 DGND 0.003654f
C10612 DVDD.n988 DGND 0.003654f
C10613 DVDD.n989 DGND 7.74e-19
C10614 DVDD.n990 DGND 0.001294f
C10615 DVDD.n991 DGND 0.001153f
C10616 DVDD.n992 DGND 0.003654f
C10617 DVDD.n993 DGND 0.003654f
C10618 DVDD.n994 DGND 2.67e-19
C10619 DVDD.n995 DGND 0.002463f
C10620 DVDD.n996 DGND 0.001167f
C10621 DVDD.t210 DGND 0.001117f
C10622 DVDD.t214 DGND 0.001117f
C10623 DVDD.n997 DGND 0.002423f
C10624 DVDD.n998 DGND 0.002849f
C10625 DVDD.n999 DGND 6.61e-19
C10626 DVDD.n1000 DGND 0.003654f
C10627 DVDD.n1001 DGND 0.003654f
C10628 DVDD.n1002 DGND 0.003654f
C10629 DVDD.n1003 DGND 0.001097f
C10630 DVDD.n1004 DGND 0.002591f
C10631 DVDD.n1005 DGND 2.18e-19
C10632 DVDD.n1006 DGND 0.004501f
C10633 DVDD.n1007 DGND 7.31e-19
C10634 DVDD.n1008 DGND 0.003654f
C10635 DVDD.n1009 DGND 0.003654f
C10636 DVDD.n1010 DGND 1.48e-19
C10637 DVDD.n1011 DGND 0.002734f
C10638 DVDD.n1012 DGND 9.42e-19
C10639 DVDD.n1013 DGND 0.002591f
C10640 DVDD.n1014 DGND 3.02e-19
C10641 DVDD.n1015 DGND 0.003654f
C10642 DVDD.n1016 DGND 0.003654f
C10643 DVDD.n1017 DGND 0.001273f
C10644 DVDD.n1018 DGND 9.21e-19
C10645 DVDD.n1019 DGND 0.003482f
C10646 DVDD.n1020 DGND 0.003654f
C10647 DVDD.n1021 DGND 0.003654f
C10648 DVDD.n1022 DGND 0.003654f
C10649 DVDD.n1023 DGND 9.7e-19
C10650 DVDD.n1024 DGND 0.011091f
C10651 DVDD.n1025 DGND 9.7e-19
C10652 DVDD.n1026 DGND 8.65e-19
C10653 DVDD.n1027 DGND 0.003654f
C10654 DVDD.n1028 DGND 0.003654f
C10655 DVDD.n1029 DGND 0.003654f
C10656 DVDD.n1030 DGND 7.17e-19
C10657 DVDD.n1031 DGND 0.00328f
C10658 DVDD.n1032 DGND 7.24e-19
C10659 DVDD.n1033 DGND 7.81e-19
C10660 DVDD.n1034 DGND 0.003654f
C10661 DVDD.n1035 DGND 0.003654f
C10662 DVDD.n1036 DGND 3.23e-19
C10663 DVDD.n1037 DGND 0.00396f
C10664 DVDD.n1038 DGND 0.001203f
C10665 DVDD.t437 DGND 0.002388f
C10666 DVDD.n1039 DGND 0.003223f
C10667 DVDD.n1040 DGND 8.16e-19
C10668 DVDD.n1041 DGND 0.003654f
C10669 DVDD.n1042 DGND 0.003654f
C10670 DVDD.n1043 DGND 0.003654f
C10671 DVDD.n1044 DGND 9.7e-19
C10672 DVDD.n1045 DGND 0.005105f
C10673 DVDD.n1046 DGND 0.002267f
C10674 DVDD.n1047 DGND 8.44e-19
C10675 DVDD.n1048 DGND 7.52e-19
C10676 DVDD.n1049 DGND 0.003654f
C10677 DVDD.n1050 DGND 0.003654f
C10678 DVDD.n1051 DGND 7.24e-19
C10679 DVDD.n1052 DGND 7.81e-19
C10680 DVDD.t942 DGND 4.69e-19
C10681 DVDD.t645 DGND 4.69e-19
C10682 DVDD.n1053 DGND 9.72e-19
C10683 DVDD.n1054 DGND 0.003043f
C10684 DVDD.t314 DGND 0.003921f
C10685 DVDD.n1055 DGND 0.002463f
C10686 DVDD.n1056 DGND 1.76e-19
C10687 DVDD.n1057 DGND 0.003654f
C10688 DVDD.n1058 DGND 0.003654f
C10689 DVDD.n1059 DGND 0.003654f
C10690 DVDD.n1060 DGND 6.61e-19
C10691 DVDD.n1061 DGND 0.002849f
C10692 DVDD.n1062 DGND 8.02e-19
C10693 DVDD.t643 DGND 0.002388f
C10694 DVDD.n1063 DGND 0.003223f
C10695 DVDD.n1064 DGND 5.7e-19
C10696 DVDD.n1065 DGND 0.003654f
C10697 DVDD.n1066 DGND 0.003654f
C10698 DVDD.n1067 DGND 0.003654f
C10699 DVDD.t527 DGND 0.00237f
C10700 DVDD.n1068 DGND 0.003608f
C10701 DVDD.t282 DGND 0.004456f
C10702 DVDD.n1069 DGND 0.00652f
C10703 DVDD.t756 DGND 0.004455f
C10704 DVDD.n1070 DGND 0.006208f
C10705 DVDD.n1071 DGND 0.003654f
C10706 DVDD.n1072 DGND 0.003654f
C10707 DVDD.n1073 DGND 0.003654f
C10708 DVDD.n1074 DGND 0.006387f
C10709 DVDD.t529 DGND 4.69e-19
C10710 DVDD.t612 DGND 4.69e-19
C10711 DVDD.n1075 DGND 9.72e-19
C10712 DVDD.n1076 DGND 0.003486f
C10713 DVDD.t578 DGND 0.001701f
C10714 DVDD.n1077 DGND 0.002688f
C10715 DVDD.n1078 DGND 9.49e-19
C10716 DVDD.n1079 DGND 0.003654f
C10717 DVDD.n1080 DGND 0.003654f
C10718 DVDD.n1081 DGND 7.88e-19
C10719 DVDD.n1082 DGND 7.81e-19
C10720 DVDD.t581 DGND 4.69e-19
C10721 DVDD.t533 DGND 4.69e-19
C10722 DVDD.n1083 DGND 9.72e-19
C10723 DVDD.n1084 DGND 0.003043f
C10724 DVDD.n1085 DGND 6.96e-19
C10725 DVDD.n1086 DGND 0.003654f
C10726 DVDD.n1087 DGND 0.003654f
C10727 DVDD.n1088 DGND 0.003654f
C10728 DVDD.n1089 DGND 8.65e-19
C10729 DVDD.t587 DGND 4.69e-19
C10730 DVDD.t39 DGND 4.69e-19
C10731 DVDD.n1090 DGND 9.72e-19
C10732 DVDD.n1091 DGND 0.003212f
C10733 DVDD.t531 DGND 0.002388f
C10734 DVDD.n1092 DGND 0.003188f
C10735 DVDD.n1093 DGND 2.32e-19
C10736 DVDD.n1094 DGND 0.003654f
C10737 DVDD.n1095 DGND 0.003654f
C10738 DVDD.n1096 DGND 7.24e-19
C10739 DVDD.n1097 DGND 7.81e-19
C10740 DVDD.t508 DGND 4.69e-19
C10741 DVDD.t589 DGND 4.69e-19
C10742 DVDD.n1098 DGND 9.72e-19
C10743 DVDD.n1099 DGND 0.003043f
C10744 DVDD.n1100 DGND 1.76e-19
C10745 DVDD.n1101 DGND 0.003654f
C10746 DVDD.n1102 DGND 0.003654f
C10747 DVDD.n1103 DGND 0.001167f
C10748 DVDD.n1104 DGND 6.61e-19
C10749 DVDD.n1105 DGND 0.002903f
C10750 DVDD.t591 DGND 0.00241f
C10751 DVDD.n1106 DGND 0.004553f
C10752 DVDD.n1107 DGND 0.008707f
C10753 DVDD.n1108 DGND 0.077519f
C10754 DVDD.n1109 DGND 0.043207f
C10755 DVDD.n1110 DGND 0.008237f
C10756 DVDD.n1111 DGND 0.002422f
C10757 DVDD.n1112 DGND 0.003654f
C10758 DVDD.t481 DGND 0.004456f
C10759 DVDD.n1113 DGND 0.006612f
C10760 DVDD.n1114 DGND 0.001104f
C10761 DVDD.n1115 DGND 6.68e-19
C10762 DVDD.n1116 DGND 0.003654f
C10763 DVDD.n1117 DGND 0.003654f
C10764 DVDD.n1118 DGND 0.003654f
C10765 DVDD.n1119 DGND 9.56e-19
C10766 DVDD.n1120 DGND 0.002828f
C10767 DVDD.n1121 DGND 3.59e-19
C10768 DVDD.n1122 DGND 0.005476f
C10769 DVDD.n1123 DGND 0.005839f
C10770 DVDD.n1124 DGND 2.04e-19
C10771 DVDD.n1125 DGND 0.003654f
C10772 DVDD.n1126 DGND 0.003654f
C10773 DVDD.n1127 DGND 9.35e-19
C10774 DVDD.t167 DGND 0.004455f
C10775 DVDD.n1128 DGND 0.006412f
C10776 DVDD.n1129 DGND 5.7e-19
C10777 DVDD.n1130 DGND 0.003654f
C10778 DVDD.n1131 DGND 0.003654f
C10779 DVDD.n1132 DGND 7.24e-19
C10780 DVDD.n1133 DGND 0.00396f
C10781 DVDD.n1134 DGND 9.14e-19
C10782 DVDD.n1135 DGND 0.003654f
C10783 DVDD.n1136 DGND 0.003654f
C10784 DVDD.n1137 DGND 2.88e-19
C10785 DVDD.n1138 DGND 0.002591f
C10786 DVDD.n1139 DGND 0.001013f
C10787 DVDD.n1140 DGND 6.68e-19
C10788 DVDD.n1141 DGND 0.003654f
C10789 DVDD.n1142 DGND 0.003654f
C10790 DVDD.n1143 DGND 6.61e-19
C10791 DVDD.n1144 DGND 0.015007f
C10792 DVDD.n1145 DGND 0.003367f
C10793 DVDD.n1146 DGND 3.45e-19
C10794 DVDD.n1147 DGND 0.003223f
C10795 DVDD.n1148 DGND 8.16e-19
C10796 DVDD.n1149 DGND 0.003654f
C10797 DVDD.n1150 DGND 0.003654f
C10798 DVDD.n1151 DGND 0.003654f
C10799 DVDD.n1152 DGND 0.001294f
C10800 DVDD.n1153 DGND 7.88e-19
C10801 DVDD.n1154 DGND 0.002495f
C10802 DVDD.n1155 DGND 0.00245f
C10803 DVDD.n1156 DGND 0.001006f
C10804 DVDD.n1157 DGND 0.003654f
C10805 DVDD.n1158 DGND 0.003654f
C10806 DVDD.n1159 DGND 3.16e-19
C10807 DVDD.n1160 DGND 0.002828f
C10808 DVDD.n1161 DGND 9.85e-19
C10809 DVDD.n1162 DGND 6.68e-19
C10810 DVDD.n1163 DGND 0.003654f
C10811 DVDD.n1164 DGND 0.003654f
C10812 DVDD.n1165 DGND 7.74e-19
C10813 DVDD.n1166 DGND 0.005302f
C10814 DVDD.t187 DGND 0.041676f
C10815 DVDD.t616 DGND 0.017326f
C10816 DVDD.t729 DGND 0.018029f
C10817 DVDD.t694 DGND 0.014985f
C10818 DVDD.t480 DGND 0.009834f
C10819 DVDD.t790 DGND 0.009834f
C10820 DVDD.t365 DGND 0.009834f
C10821 DVDD.t735 DGND 0.015219f
C10822 DVDD.t697 DGND 0.017092f
C10823 DVDD.t400 DGND 0.017092f
C10824 DVDD.t688 DGND 0.014751f
C10825 DVDD.t695 DGND 0.014751f
C10826 DVDD.t820 DGND 0.01756f
C10827 DVDD.t568 DGND 0.009834f
C10828 DVDD.t733 DGND 0.009834f
C10829 DVDD.t166 DGND 0.010419f
C10830 DVDD.t511 DGND 0.013931f
C10831 DVDD.t777 DGND 0.019667f
C10832 DVDD.t699 DGND 0.015102f
C10833 DVDD.t640 DGND 0.011239f
C10834 DVDD.t731 DGND 0.010536f
C10835 DVDD.t489 DGND 0.015804f
C10836 DVDD.t327 DGND 0.019667f
C10837 DVDD.t634 DGND 0.016155f
C10838 DVDD.t512 DGND 0.009834f
C10839 DVDD.t487 DGND 0.009834f
C10840 DVDD.t562 DGND 0.022009f
C10841 DVDD.t490 DGND 0.025521f
C10842 DVDD.t329 DGND 0.019667f
C10843 DVDD.t638 DGND 0.020253f
C10844 DVDD.t579 DGND 0.015219f
C10845 DVDD.t463 DGND 0.011239f
C10846 DVDD.t328 DGND 0.010536f
C10847 DVDD.t201 DGND 0.008429f
C10848 DVDD.t486 DGND 0.009834f
C10849 DVDD.t165 DGND 0.011239f
C10850 DVDD.t636 DGND 0.009834f
C10851 DVDD.t465 DGND 0.013931f
C10852 DVDD.t204 DGND 0.027862f
C10853 DVDD.t402 DGND 0.022009f
C10854 DVDD.t202 DGND 0.009834f
C10855 DVDD.t135 DGND 0.009834f
C10856 DVDD.t162 DGND 0.013814f
C10857 DVDD.t469 DGND 0.017794f
C10858 DVDD.n1167 DGND 0.014026f
C10859 DVDD.t498 DGND 0.013697f
C10860 DVDD.t164 DGND 0.019667f
C10861 DVDD.t206 DGND 0.019667f
C10862 DVDD.t467 DGND 0.028214f
C10863 DVDD.t674 DGND 0.027511f
C10864 DVDD.t143 DGND 0.02037f
C10865 DVDD.t497 DGND 0.019667f
C10866 DVDD.t680 DGND 0.019667f
C10867 DVDD.t147 DGND 0.012878f
C10868 DVDD.t375 DGND 0.01358f
C10869 DVDD.t911 DGND 0.018965f
C10870 DVDD.t145 DGND 0.009834f
C10871 DVDD.t813 DGND 0.009834f
C10872 DVDD.t495 DGND 0.009834f
C10873 DVDD.t369 DGND 0.009834f
C10874 DVDD.t678 DGND 0.009834f
C10875 DVDD.t909 DGND 0.010419f
C10876 DVDD.t9 DGND 0.020253f
C10877 DVDD.t494 DGND 0.012995f
C10878 DVDD.t907 DGND 0.008429f
C10879 DVDD.t142 DGND 0.009834f
C10880 DVDD.t823 DGND 0.011239f
C10881 DVDD.t676 DGND 0.009834f
C10882 DVDD.t373 DGND 0.012175f
C10883 DVDD.t144 DGND 0.021658f
C10884 DVDD.t797 DGND 0.019667f
C10885 DVDD.t906 DGND 0.008546f
C10886 DVDD.t394 DGND 0.009951f
C10887 DVDD.t199 DGND 0.011122f
C10888 DVDD.t371 DGND 0.022477f
C10889 DVDD.t751 DGND 0.031023f
C10890 DVDD.t229 DGND 0.01077f
C10891 DVDD.t404 DGND 0.01077f
C10892 DVDD.t113 DGND 0.028096f
C10893 DVDD.t321 DGND 0.028799f
C10894 DVDD.t71 DGND 0.019316f
C10895 DVDD.t0 DGND 0.009834f
C10896 DVDD.t690 DGND 0.010887f
C10897 DVDD.t323 DGND 0.019667f
C10898 DVDD.t68 DGND 0.01639f
C10899 DVDD.n1168 DGND 0.025616f
C10900 DVDD.n1169 DGND 0.005302f
C10901 DVDD.n1170 DGND 4.01e-19
C10902 DVDD.n1171 DGND 0.00328f
C10903 DVDD.n1172 DGND 7.17e-19
C10904 DVDD.n1173 DGND 0.003654f
C10905 DVDD.n1174 DGND 0.003654f
C10906 DVDD.n1175 DGND 0.003654f
C10907 DVDD.n1176 DGND 8.65e-19
C10908 DVDD.n1177 DGND 0.001294f
C10909 DVDD.n1178 DGND 0.001294f
C10910 DVDD.n1179 DGND 0.003455f
C10911 DVDD.n1180 DGND 0.001827f
C10912 DVDD.n1181 DGND 0.032405f
.ends
