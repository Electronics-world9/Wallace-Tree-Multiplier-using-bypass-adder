** sch_path: /home/student/ee5311/Wallace/inv.sch
.subckt inv A Y DVDD DGND
*.PININFO Y:O A:I DVDD:B DGND:B
XM2 Y A DVDD DVDD sky130_fd_pr__pfet_01v8 L=0.15 W=1.00 nf=1
XM1 Y A DGND DGND sky130_fd_pr__nfet_01v8 L=0.15 W=0.65 nf=1
.ends
